* NGSPICE file created from tt_um_r2r_dac_digital.ext - technology: gf180mcuD

* Black-box entry subcircuit for gf180mcu_fd_sc_mcu7t5v0__filltie abstract view
.subckt gf180mcu_fd_sc_mcu7t5v0__filltie VDD VSS
.ends

* Black-box entry subcircuit for gf180mcu_fd_sc_mcu7t5v0__fill_2 abstract view
.subckt gf180mcu_fd_sc_mcu7t5v0__fill_2 VDD VNW VPW VSS
.ends

* Black-box entry subcircuit for gf180mcu_fd_sc_mcu7t5v0__fillcap_64 abstract view
.subckt gf180mcu_fd_sc_mcu7t5v0__fillcap_64 VDD VNW VPW VSS
.ends

* Black-box entry subcircuit for gf180mcu_fd_sc_mcu7t5v0__aoi22_1 abstract view
.subckt gf180mcu_fd_sc_mcu7t5v0__aoi22_1 A1 A2 B1 B2 ZN VDD VNW VPW VSS
.ends

* Black-box entry subcircuit for gf180mcu_fd_sc_mcu7t5v0__fillcap_8 abstract view
.subckt gf180mcu_fd_sc_mcu7t5v0__fillcap_8 VDD VNW VPW VSS
.ends

* Black-box entry subcircuit for gf180mcu_fd_sc_mcu7t5v0__nand3_1 abstract view
.subckt gf180mcu_fd_sc_mcu7t5v0__nand3_1 A1 A2 A3 ZN VDD VNW VPW VSS
.ends

* Black-box entry subcircuit for gf180mcu_fd_sc_mcu7t5v0__clkinv_1 abstract view
.subckt gf180mcu_fd_sc_mcu7t5v0__clkinv_1 I ZN VDD VNW VPW VSS
.ends

* Black-box entry subcircuit for gf180mcu_fd_sc_mcu7t5v0__aoi21_2 abstract view
.subckt gf180mcu_fd_sc_mcu7t5v0__aoi21_2 A1 A2 B ZN VDD VNW VPW VSS
.ends

* Black-box entry subcircuit for gf180mcu_fd_sc_mcu7t5v0__fillcap_4 abstract view
.subckt gf180mcu_fd_sc_mcu7t5v0__fillcap_4 VDD VNW VPW VSS
.ends

* Black-box entry subcircuit for gf180mcu_fd_sc_mcu7t5v0__fill_1 abstract view
.subckt gf180mcu_fd_sc_mcu7t5v0__fill_1 VDD VNW VPW VSS
.ends

* Black-box entry subcircuit for gf180mcu_fd_sc_mcu7t5v0__oai21_4 abstract view
.subckt gf180mcu_fd_sc_mcu7t5v0__oai21_4 A1 A2 B ZN VDD VNW VPW VSS
.ends

* Black-box entry subcircuit for gf180mcu_fd_sc_mcu7t5v0__nand2_1 abstract view
.subckt gf180mcu_fd_sc_mcu7t5v0__nand2_1 A1 A2 ZN VDD VNW VPW VSS
.ends

* Black-box entry subcircuit for gf180mcu_fd_sc_mcu7t5v0__oai21_1 abstract view
.subckt gf180mcu_fd_sc_mcu7t5v0__oai21_1 A1 A2 B ZN VDD VNW VPW VSS
.ends

* Black-box entry subcircuit for gf180mcu_fd_sc_mcu7t5v0__endcap abstract view
.subckt gf180mcu_fd_sc_mcu7t5v0__endcap VDD VSS
.ends

* Black-box entry subcircuit for gf180mcu_fd_sc_mcu7t5v0__buf_2 abstract view
.subckt gf180mcu_fd_sc_mcu7t5v0__buf_2 I Z VDD VNW VPW VSS
.ends

* Black-box entry subcircuit for gf180mcu_fd_sc_mcu7t5v0__fillcap_32 abstract view
.subckt gf180mcu_fd_sc_mcu7t5v0__fillcap_32 VDD VNW VPW VSS
.ends

* Black-box entry subcircuit for gf180mcu_fd_sc_mcu7t5v0__dffq_2 abstract view
.subckt gf180mcu_fd_sc_mcu7t5v0__dffq_2 D CLK Q VDD VNW VPW VSS
.ends

* Black-box entry subcircuit for gf180mcu_fd_sc_mcu7t5v0__nor2_1 abstract view
.subckt gf180mcu_fd_sc_mcu7t5v0__nor2_1 A1 A2 ZN VDD VNW VPW VSS
.ends

* Black-box entry subcircuit for gf180mcu_fd_sc_mcu7t5v0__aoi21_1 abstract view
.subckt gf180mcu_fd_sc_mcu7t5v0__aoi21_1 A1 A2 B ZN VDD VNW VPW VSS
.ends

* Black-box entry subcircuit for gf180mcu_fd_sc_mcu7t5v0__clkbuf_8 abstract view
.subckt gf180mcu_fd_sc_mcu7t5v0__clkbuf_8 I Z VDD VNW VPW VSS
.ends

* Black-box entry subcircuit for gf180mcu_fd_sc_mcu7t5v0__inv_2 abstract view
.subckt gf180mcu_fd_sc_mcu7t5v0__inv_2 I ZN VDD VNW VPW VSS
.ends

* Black-box entry subcircuit for gf180mcu_fd_sc_mcu7t5v0__or3_1 abstract view
.subckt gf180mcu_fd_sc_mcu7t5v0__or3_1 A1 A2 A3 Z VDD VNW VPW VSS
.ends

* Black-box entry subcircuit for gf180mcu_fd_sc_mcu7t5v0__fillcap_16 abstract view
.subckt gf180mcu_fd_sc_mcu7t5v0__fillcap_16 VDD VNW VPW VSS
.ends

* Black-box entry subcircuit for gf180mcu_fd_sc_mcu7t5v0__clkbuf_1 abstract view
.subckt gf180mcu_fd_sc_mcu7t5v0__clkbuf_1 I Z VDD VNW VPW VSS
.ends

* Black-box entry subcircuit for gf180mcu_fd_sc_mcu7t5v0__nor2_2 abstract view
.subckt gf180mcu_fd_sc_mcu7t5v0__nor2_2 A1 A2 ZN VDD VNW VPW VSS
.ends

* Black-box entry subcircuit for gf180mcu_fd_sc_mcu7t5v0__oai211_1 abstract view
.subckt gf180mcu_fd_sc_mcu7t5v0__oai211_1 A1 A2 B C ZN VDD VNW VPW VSS
.ends

* Black-box entry subcircuit for gf180mcu_fd_sc_mcu7t5v0__dffq_1 abstract view
.subckt gf180mcu_fd_sc_mcu7t5v0__dffq_1 D CLK Q VDD VNW VPW VSS
.ends

* Black-box entry subcircuit for gf180mcu_fd_sc_mcu7t5v0__and4_1 abstract view
.subckt gf180mcu_fd_sc_mcu7t5v0__and4_1 A1 A2 A3 A4 Z VDD VNW VPW VSS
.ends

* Black-box entry subcircuit for gf180mcu_fd_sc_mcu7t5v0__or3_4 abstract view
.subckt gf180mcu_fd_sc_mcu7t5v0__or3_4 A1 A2 A3 Z VDD VNW VPW VSS
.ends

* Black-box entry subcircuit for gf180mcu_fd_sc_mcu7t5v0__and2_1 abstract view
.subckt gf180mcu_fd_sc_mcu7t5v0__and2_1 A1 A2 Z VDD VNW VPW VSS
.ends

* Black-box entry subcircuit for gf180mcu_fd_sc_mcu7t5v0__aoi211_1 abstract view
.subckt gf180mcu_fd_sc_mcu7t5v0__aoi211_1 A1 A2 B C ZN VDD VNW VPW VSS
.ends

* Black-box entry subcircuit for gf180mcu_fd_sc_mcu7t5v0__nor2_4 abstract view
.subckt gf180mcu_fd_sc_mcu7t5v0__nor2_4 A1 A2 ZN VDD VNW VPW VSS
.ends

* Black-box entry subcircuit for gf180mcu_fd_sc_mcu7t5v0__clkbuf_4 abstract view
.subckt gf180mcu_fd_sc_mcu7t5v0__clkbuf_4 I Z VDD VNW VPW VSS
.ends

* Black-box entry subcircuit for gf180mcu_fd_sc_mcu7t5v0__nor3_1 abstract view
.subckt gf180mcu_fd_sc_mcu7t5v0__nor3_1 A1 A2 A3 ZN VDD VNW VPW VSS
.ends

* Black-box entry subcircuit for gf180mcu_fd_sc_mcu7t5v0__and3_1 abstract view
.subckt gf180mcu_fd_sc_mcu7t5v0__and3_1 A1 A2 A3 Z VDD VNW VPW VSS
.ends

* Black-box entry subcircuit for gf180mcu_fd_sc_mcu7t5v0__xor2_2 abstract view
.subckt gf180mcu_fd_sc_mcu7t5v0__xor2_2 A1 A2 Z VDD VNW VPW VSS
.ends

* Black-box entry subcircuit for gf180mcu_fd_sc_mcu7t5v0__clkbuf_2 abstract view
.subckt gf180mcu_fd_sc_mcu7t5v0__clkbuf_2 I Z VDD VNW VPW VSS
.ends

* Black-box entry subcircuit for gf180mcu_fd_sc_mcu7t5v0__or2_4 abstract view
.subckt gf180mcu_fd_sc_mcu7t5v0__or2_4 A1 A2 Z VDD VNW VPW VSS
.ends

* Black-box entry subcircuit for gf180mcu_fd_sc_mcu7t5v0__xor2_1 abstract view
.subckt gf180mcu_fd_sc_mcu7t5v0__xor2_1 A1 A2 Z VDD VNW VPW VSS
.ends

* Black-box entry subcircuit for gf180mcu_fd_sc_mcu7t5v0__nand2_2 abstract view
.subckt gf180mcu_fd_sc_mcu7t5v0__nand2_2 A1 A2 ZN VDD VNW VPW VSS
.ends

* Black-box entry subcircuit for gf180mcu_fd_sc_mcu7t5v0__or2_2 abstract view
.subckt gf180mcu_fd_sc_mcu7t5v0__or2_2 A1 A2 Z VDD VNW VPW VSS
.ends

* Black-box entry subcircuit for gf180mcu_fd_sc_mcu7t5v0__oai22_1 abstract view
.subckt gf180mcu_fd_sc_mcu7t5v0__oai22_1 A1 A2 B1 B2 ZN VDD VNW VPW VSS
.ends

* Black-box entry subcircuit for gf180mcu_fd_sc_mcu7t5v0__and3_2 abstract view
.subckt gf180mcu_fd_sc_mcu7t5v0__and3_2 A1 A2 A3 Z VDD VNW VPW VSS
.ends

* Black-box entry subcircuit for gf180mcu_fd_sc_mcu7t5v0__dlyb_1 abstract view
.subckt gf180mcu_fd_sc_mcu7t5v0__dlyb_1 I Z VDD VNW VPW VSS
.ends

* Black-box entry subcircuit for gf180mcu_fd_sc_mcu7t5v0__inv_1 abstract view
.subckt gf180mcu_fd_sc_mcu7t5v0__inv_1 I ZN VDD VNW VPW VSS
.ends

* Black-box entry subcircuit for gf180mcu_fd_sc_mcu7t5v0__or3_2 abstract view
.subckt gf180mcu_fd_sc_mcu7t5v0__or3_2 A1 A2 A3 Z VDD VNW VPW VSS
.ends

* Black-box entry subcircuit for gf180mcu_fd_sc_mcu7t5v0__nor3_4 abstract view
.subckt gf180mcu_fd_sc_mcu7t5v0__nor3_4 A1 A2 A3 ZN VDD VNW VPW VSS
.ends

* Black-box entry subcircuit for gf180mcu_fd_sc_mcu7t5v0__buf_4 abstract view
.subckt gf180mcu_fd_sc_mcu7t5v0__buf_4 I Z VDD VNW VPW VSS
.ends

* Black-box entry subcircuit for gf180mcu_fd_sc_mcu7t5v0__oai21_2 abstract view
.subckt gf180mcu_fd_sc_mcu7t5v0__oai21_2 A1 A2 B ZN VDD VNW VPW VSS
.ends

* Black-box entry subcircuit for gf180mcu_fd_sc_mcu7t5v0__aoi221_4 abstract view
.subckt gf180mcu_fd_sc_mcu7t5v0__aoi221_4 A1 A2 B1 B2 C ZN VDD VNW VPW VSS
.ends

* Black-box entry subcircuit for gf180mcu_fd_sc_mcu7t5v0__oai211_2 abstract view
.subckt gf180mcu_fd_sc_mcu7t5v0__oai211_2 A1 A2 B C ZN VDD VNW VPW VSS
.ends

* Black-box entry subcircuit for gf180mcu_fd_sc_mcu7t5v0__aoi211_4 abstract view
.subckt gf180mcu_fd_sc_mcu7t5v0__aoi211_4 A1 A2 B C ZN VDD VNW VPW VSS
.ends

* Black-box entry subcircuit for gf180mcu_fd_sc_mcu7t5v0__or4_2 abstract view
.subckt gf180mcu_fd_sc_mcu7t5v0__or4_2 A1 A2 A3 A4 Z VDD VNW VPW VSS
.ends

* Black-box entry subcircuit for gf180mcu_fd_sc_mcu7t5v0__oai211_4 abstract view
.subckt gf180mcu_fd_sc_mcu7t5v0__oai211_4 A1 A2 B C ZN VDD VNW VPW VSS
.ends

* Black-box entry subcircuit for gf180mcu_fd_sc_mcu7t5v0__tieh abstract view
.subckt gf180mcu_fd_sc_mcu7t5v0__tieh Z VDD VNW VPW VSS
.ends

* Black-box entry subcircuit for gf180mcu_fd_sc_mcu7t5v0__buf_1 abstract view
.subckt gf180mcu_fd_sc_mcu7t5v0__buf_1 I Z VDD VNW VPW VSS
.ends

* Black-box entry subcircuit for gf180mcu_fd_sc_mcu7t5v0__oai221_2 abstract view
.subckt gf180mcu_fd_sc_mcu7t5v0__oai221_2 A1 A2 B1 B2 C ZN VDD VNW VPW VSS
.ends

* Black-box entry subcircuit for gf180mcu_fd_sc_mcu7t5v0__aoi21_4 abstract view
.subckt gf180mcu_fd_sc_mcu7t5v0__aoi21_4 A1 A2 B ZN VDD VNW VPW VSS
.ends

* Black-box entry subcircuit for gf180mcu_fd_sc_mcu7t5v0__mux2_2 abstract view
.subckt gf180mcu_fd_sc_mcu7t5v0__mux2_2 I0 I1 S Z VDD VNW VPW VSS
.ends

* Black-box entry subcircuit for gf180mcu_fd_sc_mcu7t5v0__buf_3 abstract view
.subckt gf180mcu_fd_sc_mcu7t5v0__buf_3 I Z VDD VNW VPW VSS
.ends

* Black-box entry subcircuit for gf180mcu_fd_sc_mcu7t5v0__or4_1 abstract view
.subckt gf180mcu_fd_sc_mcu7t5v0__or4_1 A1 A2 A3 A4 Z VDD VNW VPW VSS
.ends

* Black-box entry subcircuit for gf180mcu_fd_sc_mcu7t5v0__aoi221_2 abstract view
.subckt gf180mcu_fd_sc_mcu7t5v0__aoi221_2 A1 A2 B1 B2 C ZN VDD VNW VPW VSS
.ends

* Black-box entry subcircuit for gf180mcu_fd_sc_mcu7t5v0__or2_1 abstract view
.subckt gf180mcu_fd_sc_mcu7t5v0__or2_1 A1 A2 Z VDD VNW VPW VSS
.ends

* Black-box entry subcircuit for gf180mcu_fd_sc_mcu7t5v0__nand4_1 abstract view
.subckt gf180mcu_fd_sc_mcu7t5v0__nand4_1 A1 A2 A3 A4 ZN VDD VNW VPW VSS
.ends

* Black-box entry subcircuit for gf180mcu_fd_sc_mcu7t5v0__aoi221_1 abstract view
.subckt gf180mcu_fd_sc_mcu7t5v0__aoi221_1 A1 A2 B1 B2 C ZN VDD VNW VPW VSS
.ends

* Black-box entry subcircuit for gf180mcu_fd_sc_mcu7t5v0__nor3_2 abstract view
.subckt gf180mcu_fd_sc_mcu7t5v0__nor3_2 A1 A2 A3 ZN VDD VNW VPW VSS
.ends

* Black-box entry subcircuit for gf180mcu_fd_sc_mcu7t5v0__oai221_1 abstract view
.subckt gf180mcu_fd_sc_mcu7t5v0__oai221_1 A1 A2 B1 B2 C ZN VDD VNW VPW VSS
.ends

* Black-box entry subcircuit for gf180mcu_fd_sc_mcu7t5v0__inv_4 abstract view
.subckt gf180mcu_fd_sc_mcu7t5v0__inv_4 I ZN VDD VNW VPW VSS
.ends

* Black-box entry subcircuit for gf180mcu_fd_sc_mcu7t5v0__oai31_4 abstract view
.subckt gf180mcu_fd_sc_mcu7t5v0__oai31_4 A1 A2 A3 B ZN VDD VNW VPW VSS
.ends

* Black-box entry subcircuit for gf180mcu_fd_sc_mcu7t5v0__inv_3 abstract view
.subckt gf180mcu_fd_sc_mcu7t5v0__inv_3 I ZN VDD VNW VPW VSS
.ends

* Black-box entry subcircuit for gf180mcu_fd_sc_mcu7t5v0__nand3_2 abstract view
.subckt gf180mcu_fd_sc_mcu7t5v0__nand3_2 A1 A2 A3 ZN VDD VNW VPW VSS
.ends

* Black-box entry subcircuit for gf180mcu_fd_sc_mcu7t5v0__buf_8 abstract view
.subckt gf180mcu_fd_sc_mcu7t5v0__buf_8 I Z VDD VNW VPW VSS
.ends

* Black-box entry subcircuit for gf180mcu_fd_sc_mcu7t5v0__oai22_2 abstract view
.subckt gf180mcu_fd_sc_mcu7t5v0__oai22_2 A1 A2 B1 B2 ZN VDD VNW VPW VSS
.ends

* Black-box entry subcircuit for gf180mcu_fd_sc_mcu7t5v0__aoi211_2 abstract view
.subckt gf180mcu_fd_sc_mcu7t5v0__aoi211_2 A1 A2 B C ZN VDD VNW VPW VSS
.ends

* Black-box entry subcircuit for gf180mcu_fd_sc_mcu7t5v0__oai31_1 abstract view
.subckt gf180mcu_fd_sc_mcu7t5v0__oai31_1 A1 A2 A3 B ZN VDD VNW VPW VSS
.ends

.subckt tt_um_r2r_dac_digital VGND VPWR clk ena rst_n ui_in[0] ui_in[1] ui_in[2] ui_in[3]
+ ui_in[4] ui_in[5] ui_in[6] ui_in[7] uio_in[0] uio_in[1] uio_in[2] uio_in[3] uio_in[4]
+ uio_in[5] uio_in[6] uio_in[7] uio_oe[0] uio_oe[1] uio_oe[2] uio_oe[3] uio_oe[4]
+ uio_oe[5] uio_oe[6] uio_oe[7] uio_out[0] uio_out[1] uio_out[2] uio_out[3] uio_out[4]
+ uio_out[5] uio_out[6] uio_out[7] uo_out[0] uo_out[1] uo_out[2] uo_out[3] uo_out[4]
+ uo_out[5] uo_out[6] uo_out[7]
XTAP_TAPCELL_ROW_37_401 VPWR VGND gf180mcu_fd_sc_mcu7t5v0__filltie
XFILLER_27_417 VPWR VPWR VGND VGND gf180mcu_fd_sc_mcu7t5v0__fill_2
XFILLER_10_317 VPWR VPWR VGND VGND gf180mcu_fd_sc_mcu7t5v0__fillcap_64
XFILLER_22_177 VPWR VPWR VGND VGND gf180mcu_fd_sc_mcu7t5v0__fillcap_64
XFILLER_2_527 VPWR VPWR VGND VGND gf180mcu_fd_sc_mcu7t5v0__fillcap_64
X_501_ _607_/Q _519_/A2 _517_/B1 _599_/Q _504_/A1 VPWR VPWR VGND VGND gf180mcu_fd_sc_mcu7t5v0__aoi22_1
XFILLER_33_409 VPWR VPWR VGND VGND gf180mcu_fd_sc_mcu7t5v0__fillcap_8
X_432_ _399_/C _605_/D _368_/C _433_/B VPWR VPWR VGND VGND gf180mcu_fd_sc_mcu7t5v0__nand3_1
X_294_ _294_/I _489_/A1 VPWR VPWR VGND VGND gf180mcu_fd_sc_mcu7t5v0__clkinv_1
X_363_ _606_/D _321_/I _607_/D _379_/A2 VPWR VPWR VGND VGND gf180mcu_fd_sc_mcu7t5v0__aoi21_2
XFILLER_36_247 VPWR VPWR VGND VGND gf180mcu_fd_sc_mcu7t5v0__fillcap_4
XFILLER_17_483 VPWR VPWR VGND VGND gf180mcu_fd_sc_mcu7t5v0__fillcap_4
XFILLER_6_107 VPWR VPWR VGND VGND gf180mcu_fd_sc_mcu7t5v0__fillcap_64
XFILLER_11_604 VPWR VPWR VGND VGND gf180mcu_fd_sc_mcu7t5v0__fill_1
XFILLER_18_247 VPWR VPWR VGND VGND gf180mcu_fd_sc_mcu7t5v0__fillcap_64
XFILLER_33_206 VPWR VPWR VGND VGND gf180mcu_fd_sc_mcu7t5v0__fillcap_4
X_415_ _326_/B _396_/B _452_/B _443_/B VPWR VPWR VGND VGND gf180mcu_fd_sc_mcu7t5v0__oai21_4
X_346_ _460_/B _467_/C _409_/A1 VPWR VPWR VGND VGND gf180mcu_fd_sc_mcu7t5v0__nand2_1
XTAP_TAPCELL_ROW_11_186 VPWR VGND gf180mcu_fd_sc_mcu7t5v0__filltie
XTAP_TAPCELL_ROW_19_253 VPWR VGND gf180mcu_fd_sc_mcu7t5v0__filltie
XTAP_TAPCELL_ROW_2_110 VPWR VGND gf180mcu_fd_sc_mcu7t5v0__filltie
XFILLER_28_523 VPWR VPWR VGND VGND gf180mcu_fd_sc_mcu7t5v0__fill_2
XFILLER_15_206 VPWR VPWR VGND VGND gf180mcu_fd_sc_mcu7t5v0__fillcap_4
XFILLER_28_589 VPWR VPWR VGND VGND gf180mcu_fd_sc_mcu7t5v0__fillcap_4
XFILLER_7_416 VPWR VPWR VGND VGND gf180mcu_fd_sc_mcu7t5v0__fillcap_4
XFILLER_11_489 VPWR VPWR VGND VGND gf180mcu_fd_sc_mcu7t5v0__fill_1
XTAP_TAPCELL_ROW_16_223 VPWR VGND gf180mcu_fd_sc_mcu7t5v0__filltie
XFILLER_19_556 VPWR VPWR VGND VGND gf180mcu_fd_sc_mcu7t5v0__fillcap_4
XFILLER_9_66 VPWR VPWR VGND VGND gf180mcu_fd_sc_mcu7t5v0__fillcap_4
X_329_ _329_/A1 _620_/Q _329_/B _330_/A3 VPWR VPWR VGND VGND gf180mcu_fd_sc_mcu7t5v0__oai21_1
XPHY_EDGE_ROW_8_Left_47 VPWR VGND gf180mcu_fd_sc_mcu7t5v0__endcap
XTAP_TAPCELL_ROW_13_204 VPWR VGND gf180mcu_fd_sc_mcu7t5v0__filltie
XFILLER_24_570 VPWR VPWR VGND VGND gf180mcu_fd_sc_mcu7t5v0__fillcap_4
XTAP_TAPCELL_ROW_21_270 VPWR VGND gf180mcu_fd_sc_mcu7t5v0__filltie
XFILLER_38_117 VPWR VPWR VGND VGND gf180mcu_fd_sc_mcu7t5v0__fill_1
Xload_slew30 _381_/A1 _310_/I VPWR VPWR VGND VGND gf180mcu_fd_sc_mcu7t5v0__buf_2
XFILLER_25_334 VPWR VPWR VGND VGND gf180mcu_fd_sc_mcu7t5v0__fill_1
XTAP_TAPCELL_ROW_27_318 VPWR VGND gf180mcu_fd_sc_mcu7t5v0__filltie
XTAP_TAPCELL_ROW_35_384 VPWR VGND gf180mcu_fd_sc_mcu7t5v0__filltie
XFILLER_21_562 VPWR VPWR VGND VGND gf180mcu_fd_sc_mcu7t5v0__fillcap_32
XFILLER_25_389 VPWR VPWR VGND VGND gf180mcu_fd_sc_mcu7t5v0__fill_2
XFILLER_0_444 VPWR VPWR VGND VGND gf180mcu_fd_sc_mcu7t5v0__fillcap_32
X_594_ _594_/D _602_/CLK _594_/Q VPWR VPWR VGND VGND gf180mcu_fd_sc_mcu7t5v0__dffq_2
XFILLER_6_34 VPWR VPWR VGND VGND gf180mcu_fd_sc_mcu7t5v0__fill_1
XFILLER_3_282 VPWR VPWR VGND VGND gf180mcu_fd_sc_mcu7t5v0__fillcap_64
XTAP_TAPCELL_ROW_32_365 VPWR VGND gf180mcu_fd_sc_mcu7t5v0__filltie
XFILLER_22_337 VPWR VPWR VGND VGND gf180mcu_fd_sc_mcu7t5v0__fill_2
XFILLER_13_315 VPWR VPWR VGND VGND gf180mcu_fd_sc_mcu7t5v0__fill_2
XFILLER_25_142 VPWR VPWR VGND VGND gf180mcu_fd_sc_mcu7t5v0__fillcap_64
XFILLER_0_274 VPWR VPWR VGND VGND gf180mcu_fd_sc_mcu7t5v0__fillcap_32
X_577_ _575_/Z _577_/A2 _627_/D VPWR VPWR VGND VGND gf180mcu_fd_sc_mcu7t5v0__nor2_1
XFILLER_4_591 VPWR VPWR VGND VGND gf180mcu_fd_sc_mcu7t5v0__fillcap_4
XTAP_TAPCELL_ROW_37_402 VPWR VGND gf180mcu_fd_sc_mcu7t5v0__filltie
XFILLER_22_101 VPWR VPWR VGND VGND gf180mcu_fd_sc_mcu7t5v0__fillcap_4
X_500_ _500_/A1 _500_/A2 _536_/B _590_/D VPWR VPWR VGND VGND gf180mcu_fd_sc_mcu7t5v0__aoi21_1
XPHY_EDGE_ROW_37_Left_76 VPWR VGND gf180mcu_fd_sc_mcu7t5v0__endcap
Xclkbuf_3_6__f_clk clkbuf_0_clk/Z _628_/CLK VPWR VPWR VGND VGND gf180mcu_fd_sc_mcu7t5v0__clkbuf_8
X_362_ _362_/A1 _362_/A2 _463_/C _375_/B1 VPWR VPWR VGND VGND gf180mcu_fd_sc_mcu7t5v0__oai21_1
X_431_ _420_/C _444_/B _456_/A3 VPWR VPWR VGND VGND gf180mcu_fd_sc_mcu7t5v0__nand2_1
X_293_ _620_/Q _319_/A2 VPWR VPWR VGND VGND gf180mcu_fd_sc_mcu7t5v0__inv_2
XTAP_TAPCELL_ROW_8_160 VPWR VGND gf180mcu_fd_sc_mcu7t5v0__filltie
XFILLER_1_594 VPWR VPWR VGND VGND gf180mcu_fd_sc_mcu7t5v0__fillcap_8
XFILLER_32_498 VPWR VPWR VGND VGND gf180mcu_fd_sc_mcu7t5v0__fill_1
XFILLER_8_171 VPWR VPWR VGND VGND gf180mcu_fd_sc_mcu7t5v0__fillcap_4
XTAP_TAPCELL_ROW_5_130 VPWR VGND gf180mcu_fd_sc_mcu7t5v0__filltie
X_414_ _452_/C _447_/A2 _467_/C _466_/A2 VPWR VPWR VGND VGND gf180mcu_fd_sc_mcu7t5v0__aoi21_2
X_345_ _413_/B _607_/D VPWR VPWR VGND VGND gf180mcu_fd_sc_mcu7t5v0__inv_2
XFILLER_14_410 VPWR VPWR VGND VGND gf180mcu_fd_sc_mcu7t5v0__fill_2
XTAP_TAPCELL_ROW_11_187 VPWR VGND gf180mcu_fd_sc_mcu7t5v0__filltie
XTAP_TAPCELL_ROW_19_254 VPWR VGND gf180mcu_fd_sc_mcu7t5v0__filltie
XFILLER_20_468 VPWR VPWR VGND VGND gf180mcu_fd_sc_mcu7t5v0__fill_1
XPHY_EDGE_ROW_12_Right_12 VPWR VGND gf180mcu_fd_sc_mcu7t5v0__endcap
XTAP_TAPCELL_ROW_2_111 VPWR VGND gf180mcu_fd_sc_mcu7t5v0__filltie
XPHY_EDGE_ROW_21_Right_21 VPWR VGND gf180mcu_fd_sc_mcu7t5v0__endcap
XPHY_EDGE_ROW_30_Right_30 VPWR VGND gf180mcu_fd_sc_mcu7t5v0__endcap
XFILLER_3_2 VPWR VPWR VGND VGND gf180mcu_fd_sc_mcu7t5v0__fillcap_64
XFILLER_2_177 VPWR VPWR VGND VGND gf180mcu_fd_sc_mcu7t5v0__fillcap_64
XFILLER_0_36 VPWR VPWR VGND VGND gf180mcu_fd_sc_mcu7t5v0__fillcap_32
XTAP_TAPCELL_ROW_16_224 VPWR VGND gf180mcu_fd_sc_mcu7t5v0__filltie
XTAP_TAPCELL_ROW_24_290 VPWR VGND gf180mcu_fd_sc_mcu7t5v0__filltie
X_328_ _608_/Q _329_/A1 _620_/Q _328_/Z VPWR VPWR VGND VGND gf180mcu_fd_sc_mcu7t5v0__or3_1
XFILLER_36_2 VPWR VPWR VGND VGND gf180mcu_fd_sc_mcu7t5v0__fillcap_32
XPHY_EDGE_ROW_24_Left_63 VPWR VGND gf180mcu_fd_sc_mcu7t5v0__endcap
XTAP_TAPCELL_ROW_0_90 VPWR VGND gf180mcu_fd_sc_mcu7t5v0__filltie
XFILLER_0_604 VPWR VPWR VGND VGND gf180mcu_fd_sc_mcu7t5v0__fill_1
XFILLER_16_527 VPWR VPWR VGND VGND gf180mcu_fd_sc_mcu7t5v0__fillcap_64
XFILLER_28_354 VPWR VPWR VGND VGND gf180mcu_fd_sc_mcu7t5v0__fill_1
XFILLER_28_332 VPWR VPWR VGND VGND gf180mcu_fd_sc_mcu7t5v0__fillcap_16
XFILLER_28_387 VPWR VPWR VGND VGND gf180mcu_fd_sc_mcu7t5v0__fill_1
XFILLER_31_508 VPWR VPWR VGND VGND gf180mcu_fd_sc_mcu7t5v0__fillcap_16
XFILLER_11_276 VPWR VPWR VGND VGND gf180mcu_fd_sc_mcu7t5v0__fillcap_4
XTAP_TAPCELL_ROW_21_271 VPWR VGND gf180mcu_fd_sc_mcu7t5v0__filltie
XFILLER_3_486 VPWR VPWR VGND VGND gf180mcu_fd_sc_mcu7t5v0__fillcap_4
Xload_slew42 uio_out[2] _639_/I VPWR VPWR VGND VGND gf180mcu_fd_sc_mcu7t5v0__clkbuf_1
XFILLER_19_354 VPWR VPWR VGND VGND gf180mcu_fd_sc_mcu7t5v0__fill_1
XFILLER_19_376 VPWR VPWR VGND VGND gf180mcu_fd_sc_mcu7t5v0__fill_2
XFILLER_19_398 VPWR VPWR VGND VGND gf180mcu_fd_sc_mcu7t5v0__fill_1
XFILLER_25_313 VPWR VPWR VGND VGND gf180mcu_fd_sc_mcu7t5v0__fillcap_4
XFILLER_25_324 VPWR VPWR VGND VGND gf180mcu_fd_sc_mcu7t5v0__fillcap_8
XTAP_TAPCELL_ROW_27_319 VPWR VGND gf180mcu_fd_sc_mcu7t5v0__filltie
XTAP_TAPCELL_ROW_35_385 VPWR VGND gf180mcu_fd_sc_mcu7t5v0__filltie
XFILLER_0_478 VPWR VPWR VGND VGND gf180mcu_fd_sc_mcu7t5v0__fillcap_32
X_593_ _593_/D _602_/CLK _593_/Q VPWR VPWR VGND VGND gf180mcu_fd_sc_mcu7t5v0__dffq_2
XFILLER_31_349 VPWR VPWR VGND VGND gf180mcu_fd_sc_mcu7t5v0__fill_1
XTAP_TAPCELL_ROW_32_366 VPWR VGND gf180mcu_fd_sc_mcu7t5v0__filltie
XPHY_EDGE_ROW_6_Right_6 VPWR VGND gf180mcu_fd_sc_mcu7t5v0__endcap
XPHY_EDGE_ROW_11_Left_50 VPWR VGND gf180mcu_fd_sc_mcu7t5v0__endcap
XFILLER_13_349 VPWR VPWR VGND VGND gf180mcu_fd_sc_mcu7t5v0__fill_1
XFILLER_15_66 VPWR VPWR VGND VGND gf180mcu_fd_sc_mcu7t5v0__fillcap_4
X_576_ _627_/Q _573_/Z _578_/B _577_/A2 VPWR VPWR VGND VGND gf180mcu_fd_sc_mcu7t5v0__oai21_1
XTAP_TAPCELL_ROW_37_403 VPWR VGND gf180mcu_fd_sc_mcu7t5v0__filltie
XFILLER_35_430 VPWR VPWR VGND VGND gf180mcu_fd_sc_mcu7t5v0__fillcap_8
XFILLER_27_419 VPWR VPWR VGND VGND gf180mcu_fd_sc_mcu7t5v0__fill_1
XFILLER_18_419 VPWR VPWR VGND VGND gf180mcu_fd_sc_mcu7t5v0__fillcap_8
X_361_ _608_/D _474_/C _463_/C VPWR VPWR VGND VGND gf180mcu_fd_sc_mcu7t5v0__nor2_2
X_430_ _455_/B _395_/B _430_/B _454_/C _436_/A2 VPWR VPWR VGND VGND gf180mcu_fd_sc_mcu7t5v0__oai211_1
X_292_ _292_/I _329_/A1 VPWR VPWR VGND VGND gf180mcu_fd_sc_mcu7t5v0__inv_2
XFILLER_26_496 VPWR VPWR VGND VGND gf180mcu_fd_sc_mcu7t5v0__fill_2
XTAP_TAPCELL_ROW_8_161 VPWR VGND gf180mcu_fd_sc_mcu7t5v0__filltie
XFILLER_1_562 VPWR VPWR VGND VGND gf180mcu_fd_sc_mcu7t5v0__fillcap_32
XFILLER_32_411 VPWR VPWR VGND VGND gf180mcu_fd_sc_mcu7t5v0__fillcap_8
X_628_ _628_/D _628_/CLK _628_/Q VPWR VPWR VGND VGND gf180mcu_fd_sc_mcu7t5v0__dffq_1
XFILLER_32_466 VPWR VPWR VGND VGND gf180mcu_fd_sc_mcu7t5v0__fill_2
X_559_ _617_/Q _618_/Q _619_/Q _558_/Z _620_/D VPWR VPWR VGND VGND gf180mcu_fd_sc_mcu7t5v0__and4_1
XFILLER_35_260 VPWR VPWR VGND VGND gf180mcu_fd_sc_mcu7t5v0__fillcap_4
XFILLER_23_422 VPWR VPWR VGND VGND gf180mcu_fd_sc_mcu7t5v0__fillcap_16
XFILLER_12_34 VPWR VPWR VGND VGND gf180mcu_fd_sc_mcu7t5v0__fill_1
XTAP_TAPCELL_ROW_5_131 VPWR VGND gf180mcu_fd_sc_mcu7t5v0__filltie
XFILLER_14_422 VPWR VPWR VGND VGND gf180mcu_fd_sc_mcu7t5v0__fill_1
X_413_ _406_/B _360_/C _413_/B _417_/B1 VPWR VPWR VGND VGND gf180mcu_fd_sc_mcu7t5v0__aoi21_1
X_344_ _532_/B _377_/A1 _377_/A2 _452_/B VPWR VPWR VGND VGND gf180mcu_fd_sc_mcu7t5v0__or3_4
XFILLER_5_142 VPWR VPWR VGND VGND gf180mcu_fd_sc_mcu7t5v0__fillcap_64
XFILLER_17_282 VPWR VPWR VGND VGND gf180mcu_fd_sc_mcu7t5v0__fill_2
XTAP_TAPCELL_ROW_19_255 VPWR VGND gf180mcu_fd_sc_mcu7t5v0__filltie
XFILLER_20_403 VPWR VPWR VGND VGND gf180mcu_fd_sc_mcu7t5v0__fill_1
XFILLER_32_241 VPWR VPWR VGND VGND gf180mcu_fd_sc_mcu7t5v0__fillcap_4
XFILLER_9_492 VPWR VPWR VGND VGND gf180mcu_fd_sc_mcu7t5v0__fillcap_64
XFILLER_28_558 VPWR VPWR VGND VGND gf180mcu_fd_sc_mcu7t5v0__fillcap_16
XFILLER_23_66 VPWR VPWR VGND VGND gf180mcu_fd_sc_mcu7t5v0__fillcap_4
XFILLER_3_602 VPWR VPWR VGND VGND gf180mcu_fd_sc_mcu7t5v0__fill_2
XFILLER_2_101 VPWR VPWR VGND VGND gf180mcu_fd_sc_mcu7t5v0__fillcap_4
XFILLER_14_241 VPWR VPWR VGND VGND gf180mcu_fd_sc_mcu7t5v0__fillcap_4
XTAP_TAPCELL_ROW_16_225 VPWR VGND gf180mcu_fd_sc_mcu7t5v0__filltie
XFILLER_27_580 VPWR VPWR VGND VGND gf180mcu_fd_sc_mcu7t5v0__fill_1
XFILLER_6_451 VPWR VPWR VGND VGND gf180mcu_fd_sc_mcu7t5v0__fillcap_4
X_327_ _312_/Z _466_/A1 _467_/B _333_/A1 VPWR VPWR VGND VGND gf180mcu_fd_sc_mcu7t5v0__nand3_1
XTAP_TAPCELL_ROW_24_291 VPWR VGND gf180mcu_fd_sc_mcu7t5v0__filltie
XTAP_TAPCELL_ROW_0_80 VPWR VGND gf180mcu_fd_sc_mcu7t5v0__filltie
XTAP_TAPCELL_ROW_0_91 VPWR VGND gf180mcu_fd_sc_mcu7t5v0__filltie
XFILLER_29_2 VPWR VPWR VGND VGND gf180mcu_fd_sc_mcu7t5v0__fillcap_64
XFILLER_33_594 VPWR VPWR VGND VGND gf180mcu_fd_sc_mcu7t5v0__fillcap_8
XFILLER_18_591 VPWR VPWR VGND VGND gf180mcu_fd_sc_mcu7t5v0__fillcap_4
XTAP_TAPCELL_ROW_21_272 VPWR VGND gf180mcu_fd_sc_mcu7t5v0__filltie
XFILLER_24_594 VPWR VPWR VGND VGND gf180mcu_fd_sc_mcu7t5v0__fill_1
Xload_slew32 uio_out[7] _644_/I VPWR VPWR VGND VGND gf180mcu_fd_sc_mcu7t5v0__clkbuf_1
XFILLER_19_344 VPWR VPWR VGND VGND gf180mcu_fd_sc_mcu7t5v0__fillcap_4
XFILLER_19_388 VPWR VPWR VGND VGND gf180mcu_fd_sc_mcu7t5v0__fillcap_8
Xload_slew65 _365_/B _450_/B VPWR VPWR VGND VGND gf180mcu_fd_sc_mcu7t5v0__buf_2
Xload_slew21 _301_/I _437_/B VPWR VPWR VGND VGND gf180mcu_fd_sc_mcu7t5v0__buf_2
XFILLER_15_594 VPWR VPWR VGND VGND gf180mcu_fd_sc_mcu7t5v0__fillcap_8
XFILLER_30_564 VPWR VPWR VGND VGND gf180mcu_fd_sc_mcu7t5v0__fillcap_4
XFILLER_30_597 VPWR VPWR VGND VGND gf180mcu_fd_sc_mcu7t5v0__fillcap_8
XTAP_TAPCELL_ROW_35_386 VPWR VGND gf180mcu_fd_sc_mcu7t5v0__filltie
XFILLER_20_34 VPWR VPWR VGND VGND gf180mcu_fd_sc_mcu7t5v0__fill_1
X_592_ _592_/D _602_/CLK _592_/Q VPWR VPWR VGND VGND gf180mcu_fd_sc_mcu7t5v0__dffq_2
XFILLER_12_597 VPWR VPWR VGND VGND gf180mcu_fd_sc_mcu7t5v0__fillcap_8
XFILLER_22_306 VPWR VPWR VGND VGND gf180mcu_fd_sc_mcu7t5v0__fill_1
XFILLER_34_177 VPWR VPWR VGND VGND gf180mcu_fd_sc_mcu7t5v0__fillcap_64
XFILLER_22_317 VPWR VPWR VGND VGND gf180mcu_fd_sc_mcu7t5v0__fill_2
XFILLER_22_339 VPWR VPWR VGND VGND gf180mcu_fd_sc_mcu7t5v0__fill_1
XFILLER_22_328 VPWR VPWR VGND VGND gf180mcu_fd_sc_mcu7t5v0__fillcap_4
XFILLER_38_450 VPWR VPWR VGND VGND gf180mcu_fd_sc_mcu7t5v0__fill_2
XFILLER_13_317 VPWR VPWR VGND VGND gf180mcu_fd_sc_mcu7t5v0__fill_1
XFILLER_31_66 VPWR VPWR VGND VGND gf180mcu_fd_sc_mcu7t5v0__fillcap_4
X_644_ _644_/I uo_out[7] VPWR VPWR VGND VGND gf180mcu_fd_sc_mcu7t5v0__buf_2
X_575_ _627_/Q _573_/Z _575_/Z VPWR VPWR VGND VGND gf180mcu_fd_sc_mcu7t5v0__and2_1
XFILLER_29_483 VPWR VPWR VGND VGND gf180mcu_fd_sc_mcu7t5v0__fill_1
XFILLER_16_177 VPWR VPWR VGND VGND gf180mcu_fd_sc_mcu7t5v0__fillcap_64
XFILLER_31_136 VPWR VPWR VGND VGND gf180mcu_fd_sc_mcu7t5v0__fillcap_4
XFILLER_8_387 VPWR VPWR VGND VGND gf180mcu_fd_sc_mcu7t5v0__fillcap_64
XTAP_TAPCELL_ROW_37_404 VPWR VGND gf180mcu_fd_sc_mcu7t5v0__filltie
XFILLER_11_2 VPWR VPWR VGND VGND gf180mcu_fd_sc_mcu7t5v0__fillcap_64
XFILLER_13_136 VPWR VPWR VGND VGND gf180mcu_fd_sc_mcu7t5v0__fillcap_4
X_360_ _310_/I _321_/I _413_/B _360_/C _362_/A2 VPWR VPWR VGND VGND gf180mcu_fd_sc_mcu7t5v0__aoi211_1
X_291_ _621_/Q _305_/B VPWR VPWR VGND VGND gf180mcu_fd_sc_mcu7t5v0__clkinv_1
XFILLER_5_346 VPWR VPWR VGND VGND gf180mcu_fd_sc_mcu7t5v0__fillcap_4
XTAP_TAPCELL_ROW_8_162 VPWR VGND gf180mcu_fd_sc_mcu7t5v0__filltie
XFILLER_32_401 VPWR VPWR VGND VGND gf180mcu_fd_sc_mcu7t5v0__fill_1
X_627_ _627_/D _627_/CLK _627_/Q VPWR VPWR VGND VGND gf180mcu_fd_sc_mcu7t5v0__dffq_1
X_558_ _613_/Q _614_/Q _612_/D _546_/Z _558_/Z VPWR VPWR VGND VGND gf180mcu_fd_sc_mcu7t5v0__and4_1
X_489_ _489_/A1 _489_/A2 _517_/B1 VPWR VPWR VGND VGND gf180mcu_fd_sc_mcu7t5v0__nor2_4
XFILLER_27_206 VPWR VPWR VGND VGND gf180mcu_fd_sc_mcu7t5v0__fillcap_4
XTAP_TAPCELL_ROW_5_132 VPWR VGND gf180mcu_fd_sc_mcu7t5v0__filltie
XFILLER_14_412 VPWR VPWR VGND VGND gf180mcu_fd_sc_mcu7t5v0__fill_1
X_412_ _467_/C _351_/Z _460_/B _417_/A2 VPWR VPWR VGND VGND gf180mcu_fd_sc_mcu7t5v0__oai21_1
X_343_ _365_/B _426_/C _472_/A1 VPWR VPWR VGND VGND gf180mcu_fd_sc_mcu7t5v0__nand2_1
XFILLER_37_515 VPWR VPWR VGND VGND gf180mcu_fd_sc_mcu7t5v0__fill_2
XFILLER_9_482 VPWR VPWR VGND VGND gf180mcu_fd_sc_mcu7t5v0__fillcap_8
XFILLER_28_515 VPWR VPWR VGND VGND gf180mcu_fd_sc_mcu7t5v0__fillcap_8
XFILLER_11_404 VPWR VPWR VGND VGND gf180mcu_fd_sc_mcu7t5v0__fill_2
XFILLER_11_426 VPWR VPWR VGND VGND gf180mcu_fd_sc_mcu7t5v0__fill_2
XFILLER_23_297 VPWR VPWR VGND VGND gf180mcu_fd_sc_mcu7t5v0__fill_2
XFILLER_19_548 VPWR VPWR VGND VGND gf180mcu_fd_sc_mcu7t5v0__fillcap_8
X_326_ _401_/A1 _321_/I _326_/B _449_/B VPWR VPWR VGND VGND gf180mcu_fd_sc_mcu7t5v0__aoi21_1
XTAP_TAPCELL_ROW_16_226 VPWR VGND gf180mcu_fd_sc_mcu7t5v0__filltie
XTAP_TAPCELL_ROW_24_292 VPWR VGND gf180mcu_fd_sc_mcu7t5v0__filltie
XTAP_TAPCELL_ROW_0_81 VPWR VGND gf180mcu_fd_sc_mcu7t5v0__filltie
XTAP_TAPCELL_ROW_0_92 VPWR VGND gf180mcu_fd_sc_mcu7t5v0__filltie
XFILLER_33_562 VPWR VPWR VGND VGND gf180mcu_fd_sc_mcu7t5v0__fillcap_32
XFILLER_18_34 VPWR VPWR VGND VGND gf180mcu_fd_sc_mcu7t5v0__fill_1
XFILLER_11_212 VPWR VPWR VGND VGND gf180mcu_fd_sc_mcu7t5v0__fillcap_64
XFILLER_38_109 VPWR VPWR VGND VGND gf180mcu_fd_sc_mcu7t5v0__fillcap_8
XFILLER_3_422 VPWR VPWR VGND VGND gf180mcu_fd_sc_mcu7t5v0__fillcap_64
Xload_slew44 uio_out[1] _638_/I VPWR VPWR VGND VGND gf180mcu_fd_sc_mcu7t5v0__clkbuf_1
Xload_slew66 _503_/A2 _519_/B1 VPWR VPWR VGND VGND gf180mcu_fd_sc_mcu7t5v0__clkbuf_4
XFILLER_19_323 VPWR VPWR VGND VGND gf180mcu_fd_sc_mcu7t5v0__fillcap_4
XTAP_TAPCELL_ROW_29_340 VPWR VGND gf180mcu_fd_sc_mcu7t5v0__filltie
XFILLER_15_562 VPWR VPWR VGND VGND gf180mcu_fd_sc_mcu7t5v0__fillcap_32
X_309_ _564_/A2 _306_/Z _568_/B _381_/A1 VPWR VPWR VGND VGND gf180mcu_fd_sc_mcu7t5v0__oai21_4
XFILLER_37_142 VPWR VPWR VGND VGND gf180mcu_fd_sc_mcu7t5v0__fillcap_64
XTAP_TAPCELL_ROW_35_387 VPWR VGND gf180mcu_fd_sc_mcu7t5v0__filltie
XFILLER_25_304 VPWR VPWR VGND VGND gf180mcu_fd_sc_mcu7t5v0__fillcap_4
XFILLER_25_348 VPWR VPWR VGND VGND gf180mcu_fd_sc_mcu7t5v0__fill_2
XFILLER_21_554 VPWR VPWR VGND VGND gf180mcu_fd_sc_mcu7t5v0__fillcap_4
X_591_ _591_/D _595_/CLK _591_/Q VPWR VPWR VGND VGND gf180mcu_fd_sc_mcu7t5v0__dffq_2
XTAP_TAPCELL_ROW_26_310 VPWR VGND gf180mcu_fd_sc_mcu7t5v0__filltie
XFILLER_29_66 VPWR VPWR VGND VGND gf180mcu_fd_sc_mcu7t5v0__fillcap_4
XFILLER_12_521 VPWR VPWR VGND VGND gf180mcu_fd_sc_mcu7t5v0__fillcap_4
XFILLER_24_392 VPWR VPWR VGND VGND gf180mcu_fd_sc_mcu7t5v0__fillcap_8
XFILLER_31_318 VPWR VPWR VGND VGND gf180mcu_fd_sc_mcu7t5v0__fill_2
XFILLER_6_37 VPWR VPWR VGND VGND gf180mcu_fd_sc_mcu7t5v0__fillcap_64
XFILLER_35_602 VPWR VPWR VGND VGND gf180mcu_fd_sc_mcu7t5v0__fill_2
XFILLER_34_101 VPWR VPWR VGND VGND gf180mcu_fd_sc_mcu7t5v0__fillcap_4
XFILLER_15_381 VPWR VPWR VGND VGND gf180mcu_fd_sc_mcu7t5v0__fill_2
XFILLER_19_142 VPWR VPWR VGND VGND gf180mcu_fd_sc_mcu7t5v0__fillcap_64
XFILLER_15_392 VPWR VPWR VGND VGND gf180mcu_fd_sc_mcu7t5v0__fillcap_8
X_643_ _643_/I uo_out[6] VPWR VPWR VGND VGND gf180mcu_fd_sc_mcu7t5v0__buf_2
XFILLER_16_101 VPWR VPWR VGND VGND gf180mcu_fd_sc_mcu7t5v0__fillcap_4
XFILLER_17_602 VPWR VPWR VGND VGND gf180mcu_fd_sc_mcu7t5v0__fill_2
X_574_ wire52/Z _574_/A2 _573_/Z _626_/D VPWR VPWR VGND VGND gf180mcu_fd_sc_mcu7t5v0__nor3_1
XFILLER_8_311 VPWR VPWR VGND VGND gf180mcu_fd_sc_mcu7t5v0__fillcap_4
XTAP_TAPCELL_ROW_37_405 VPWR VGND gf180mcu_fd_sc_mcu7t5v0__filltie
XFILLER_26_34 VPWR VPWR VGND VGND gf180mcu_fd_sc_mcu7t5v0__fill_1
X_290_ _625_/Q _329_/B VPWR VPWR VGND VGND gf180mcu_fd_sc_mcu7t5v0__clkinv_1
X_488_ _489_/A1 _295_/I _517_/A2 VPWR VPWR VGND VGND gf180mcu_fd_sc_mcu7t5v0__nor2_4
XFILLER_32_468 VPWR VPWR VGND VGND gf180mcu_fd_sc_mcu7t5v0__fill_1
XFILLER_17_487 VPWR VPWR VGND VGND gf180mcu_fd_sc_mcu7t5v0__fill_2
X_557_ wire52/Z _556_/Z _619_/D VPWR VPWR VGND VGND gf180mcu_fd_sc_mcu7t5v0__nor2_1
X_626_ _626_/D _627_/CLK _626_/Q VPWR VPWR VGND VGND gf180mcu_fd_sc_mcu7t5v0__dffq_1
XFILLER_23_413 VPWR VPWR VGND VGND gf180mcu_fd_sc_mcu7t5v0__fillcap_4
XFILLER_10_107 VPWR VPWR VGND VGND gf180mcu_fd_sc_mcu7t5v0__fillcap_64
XFILLER_2_317 VPWR VPWR VGND VGND gf180mcu_fd_sc_mcu7t5v0__fillcap_64
XFILLER_37_66 VPWR VPWR VGND VGND gf180mcu_fd_sc_mcu7t5v0__fillcap_4
XTAP_TAPCELL_ROW_5_133 VPWR VGND gf180mcu_fd_sc_mcu7t5v0__filltie
XFILLER_14_457 VPWR VPWR VGND VGND gf180mcu_fd_sc_mcu7t5v0__fillcap_64
X_411_ _467_/C _445_/A2 _422_/A4 _411_/Z VPWR VPWR VGND VGND gf180mcu_fd_sc_mcu7t5v0__and3_1
XFILLER_26_295 VPWR VPWR VGND VGND gf180mcu_fd_sc_mcu7t5v0__fillcap_8
X_342_ _474_/C _610_/D _475_/B VPWR VPWR VGND VGND gf180mcu_fd_sc_mcu7t5v0__nor2_2
X_609_ _609_/D _628_/CLK _609_/Q VPWR VPWR VGND VGND gf180mcu_fd_sc_mcu7t5v0__dffq_1
XFILLER_9_450 VPWR VPWR VGND VGND gf180mcu_fd_sc_mcu7t5v0__fillcap_32
XFILLER_20_449 VPWR VPWR VGND VGND gf180mcu_fd_sc_mcu7t5v0__fillcap_4
XTAP_TAPCELL_ROW_2_103 VPWR VGND gf180mcu_fd_sc_mcu7t5v0__filltie
XFILLER_28_527 VPWR VPWR VGND VGND gf180mcu_fd_sc_mcu7t5v0__fill_2
XFILLER_23_276 VPWR VPWR VGND VGND gf180mcu_fd_sc_mcu7t5v0__fillcap_4
XFILLER_3_604 VPWR VPWR VGND VGND gf180mcu_fd_sc_mcu7t5v0__fill_1
XFILLER_19_516 VPWR VPWR VGND VGND gf180mcu_fd_sc_mcu7t5v0__fillcap_32
X_325_ _452_/C _325_/A2 _467_/B VPWR VPWR VGND VGND gf180mcu_fd_sc_mcu7t5v0__xor2_2
XFILLER_14_287 VPWR VPWR VGND VGND gf180mcu_fd_sc_mcu7t5v0__fill_2
XTAP_TAPCELL_ROW_16_227 VPWR VGND gf180mcu_fd_sc_mcu7t5v0__filltie
XTAP_TAPCELL_ROW_24_293 VPWR VGND gf180mcu_fd_sc_mcu7t5v0__filltie
XTAP_TAPCELL_ROW_0_82 VPWR VGND gf180mcu_fd_sc_mcu7t5v0__filltie
XTAP_TAPCELL_ROW_0_93 VPWR VGND gf180mcu_fd_sc_mcu7t5v0__filltie
XFILLER_16_508 VPWR VPWR VGND VGND gf180mcu_fd_sc_mcu7t5v0__fillcap_16
XFILLER_34_34 VPWR VPWR VGND VGND gf180mcu_fd_sc_mcu7t5v0__fill_1
XFILLER_24_563 VPWR VPWR VGND VGND gf180mcu_fd_sc_mcu7t5v0__fill_2
XFILLER_7_206 VPWR VPWR VGND VGND gf180mcu_fd_sc_mcu7t5v0__fillcap_4
Xclkload0 _607_/CLK clkload0/Z VPWR VPWR VGND VGND gf180mcu_fd_sc_mcu7t5v0__clkbuf_2
XFILLER_1_2 VPWR VPWR VGND VGND gf180mcu_fd_sc_mcu7t5v0__fillcap_64
Xload_slew34 uio_out[6] _643_/I VPWR VPWR VGND VGND gf180mcu_fd_sc_mcu7t5v0__clkbuf_1
XFILLER_19_335 VPWR VPWR VGND VGND gf180mcu_fd_sc_mcu7t5v0__fill_1
XPHY_EDGE_ROW_28_Left_67 VPWR VGND gf180mcu_fd_sc_mcu7t5v0__endcap
X_308_ _564_/A2 _306_/Z _308_/Z VPWR VPWR VGND VGND gf180mcu_fd_sc_mcu7t5v0__or2_4
XFILLER_34_2 VPWR VPWR VGND VGND gf180mcu_fd_sc_mcu7t5v0__fillcap_32
XTAP_TAPCELL_ROW_35_388 VPWR VGND gf180mcu_fd_sc_mcu7t5v0__filltie
X_590_ _590_/D _595_/CLK _590_/Q VPWR VPWR VGND VGND gf180mcu_fd_sc_mcu7t5v0__dffq_2
XTAP_TAPCELL_ROW_26_311 VPWR VGND gf180mcu_fd_sc_mcu7t5v0__filltie
XFILLER_24_371 VPWR VPWR VGND VGND gf180mcu_fd_sc_mcu7t5v0__fillcap_4
XFILLER_22_319 VPWR VPWR VGND VGND gf180mcu_fd_sc_mcu7t5v0__fill_1
XTAP_TAPCELL_ROW_32_358 VPWR VGND gf180mcu_fd_sc_mcu7t5v0__filltie
X_642_ _642_/I uo_out[5] VPWR VPWR VGND VGND gf180mcu_fd_sc_mcu7t5v0__buf_2
XPHY_EDGE_ROW_19_Right_19 VPWR VGND gf180mcu_fd_sc_mcu7t5v0__endcap
X_573_ _626_/Q _625_/Q _567_/Z _573_/Z VPWR VPWR VGND VGND gf180mcu_fd_sc_mcu7t5v0__and3_1
Xclkbuf_3_1__f_clk clkbuf_0_clk/Z _607_/CLK VPWR VPWR VGND VGND gf180mcu_fd_sc_mcu7t5v0__clkbuf_8
XPHY_EDGE_ROW_28_Right_28 VPWR VGND gf180mcu_fd_sc_mcu7t5v0__endcap
XPHY_EDGE_ROW_37_Right_37 VPWR VGND gf180mcu_fd_sc_mcu7t5v0__endcap
XTAP_TAPCELL_ROW_37_406 VPWR VGND gf180mcu_fd_sc_mcu7t5v0__filltie
XFILLER_30_171 VPWR VPWR VGND VGND gf180mcu_fd_sc_mcu7t5v0__fillcap_4
XPHY_EDGE_ROW_15_Left_54 VPWR VGND gf180mcu_fd_sc_mcu7t5v0__endcap
XFILLER_17_422 VPWR VPWR VGND VGND gf180mcu_fd_sc_mcu7t5v0__fill_1
X_625_ _625_/D _627_/CLK _625_/Q VPWR VPWR VGND VGND gf180mcu_fd_sc_mcu7t5v0__dffq_1
XFILLER_29_282 VPWR VPWR VGND VGND gf180mcu_fd_sc_mcu7t5v0__fillcap_32
X_487_ input2/Z _519_/B1 _522_/A1 VPWR VPWR VGND VGND gf180mcu_fd_sc_mcu7t5v0__nand2_1
XFILLER_12_171 VPWR VPWR VGND VGND gf180mcu_fd_sc_mcu7t5v0__fillcap_4
X_556_ _619_/Q _556_/A2 _556_/Z VPWR VPWR VGND VGND gf180mcu_fd_sc_mcu7t5v0__xor2_1
XFILLER_4_381 VPWR VPWR VGND VGND gf180mcu_fd_sc_mcu7t5v0__fillcap_4
XFILLER_12_37 VPWR VPWR VGND VGND gf180mcu_fd_sc_mcu7t5v0__fillcap_64
XPHY_EDGE_ROW_0_Left_39 VPWR VGND gf180mcu_fd_sc_mcu7t5v0__endcap
XTAP_TAPCELL_ROW_5_134 VPWR VGND gf180mcu_fd_sc_mcu7t5v0__filltie
X_410_ _444_/B _410_/A2 _410_/B _418_/B VPWR VPWR VGND VGND gf180mcu_fd_sc_mcu7t5v0__aoi21_1
XFILLER_26_241 VPWR VPWR VGND VGND gf180mcu_fd_sc_mcu7t5v0__fillcap_4
X_341_ _426_/C _610_/D VPWR VPWR VGND VGND gf180mcu_fd_sc_mcu7t5v0__inv_2
X_608_ _608_/D _611_/CLK _608_/Q VPWR VPWR VGND VGND gf180mcu_fd_sc_mcu7t5v0__dffq_1
X_539_ _613_/Q _612_/Q _539_/B _613_/D VPWR VPWR VGND VGND gf180mcu_fd_sc_mcu7t5v0__aoi21_1
XFILLER_13_480 VPWR VPWR VGND VGND gf180mcu_fd_sc_mcu7t5v0__fillcap_8
XTAP_TAPCELL_ROW_2_104 VPWR VGND gf180mcu_fd_sc_mcu7t5v0__filltie
XFILLER_11_439 VPWR VPWR VGND VGND gf180mcu_fd_sc_mcu7t5v0__fill_2
XFILLER_11_428 VPWR VPWR VGND VGND gf180mcu_fd_sc_mcu7t5v0__fill_1
XFILLER_23_299 VPWR VPWR VGND VGND gf180mcu_fd_sc_mcu7t5v0__fill_1
XTAP_TAPCELL_ROW_16_228 VPWR VGND gf180mcu_fd_sc_mcu7t5v0__filltie
XTAP_TAPCELL_ROW_24_294 VPWR VGND gf180mcu_fd_sc_mcu7t5v0__filltie
X_324_ _452_/C _400_/A3 _474_/A1 VPWR VPWR VGND VGND gf180mcu_fd_sc_mcu7t5v0__nand2_1
XTAP_TAPCELL_ROW_0_83 VPWR VGND gf180mcu_fd_sc_mcu7t5v0__filltie
XTAP_TAPCELL_ROW_0_94 VPWR VGND gf180mcu_fd_sc_mcu7t5v0__filltie
XFILLER_20_247 VPWR VPWR VGND VGND gf180mcu_fd_sc_mcu7t5v0__fillcap_32
XFILLER_24_520 VPWR VPWR VGND VGND gf180mcu_fd_sc_mcu7t5v0__fillcap_4
XFILLER_28_303 VPWR VPWR VGND VGND gf180mcu_fd_sc_mcu7t5v0__fillcap_4
Xclkload1 _595_/CLK clkload1/Z VPWR VPWR VGND VGND gf180mcu_fd_sc_mcu7t5v0__clkbuf_2
XFILLER_24_597 VPWR VPWR VGND VGND gf180mcu_fd_sc_mcu7t5v0__fillcap_8
XPHY_EDGE_ROW_3_Left_42 VPWR VGND gf180mcu_fd_sc_mcu7t5v0__endcap
Xload_slew46 uio_out[0] _637_/I VPWR VPWR VGND VGND gf180mcu_fd_sc_mcu7t5v0__clkbuf_1
XFILLER_34_328 VPWR VPWR VGND VGND gf180mcu_fd_sc_mcu7t5v0__fill_1
XFILLER_34_317 VPWR VPWR VGND VGND gf180mcu_fd_sc_mcu7t5v0__fillcap_4
X_307_ _564_/A2 _306_/Z _401_/A1 VPWR VPWR VGND VGND gf180mcu_fd_sc_mcu7t5v0__nor2_2
XFILLER_30_523 VPWR VPWR VGND VGND gf180mcu_fd_sc_mcu7t5v0__fill_2
XFILLER_27_2 VPWR VPWR VGND VGND gf180mcu_fd_sc_mcu7t5v0__fillcap_64
XFILLER_1_72 VPWR VPWR VGND VGND gf180mcu_fd_sc_mcu7t5v0__fillcap_64
XFILLER_25_317 VPWR VPWR VGND VGND gf180mcu_fd_sc_mcu7t5v0__fill_2
XTAP_TAPCELL_ROW_35_389 VPWR VGND gf180mcu_fd_sc_mcu7t5v0__filltie
XFILLER_20_37 VPWR VPWR VGND VGND gf180mcu_fd_sc_mcu7t5v0__fillcap_64
XFILLER_16_317 VPWR VPWR VGND VGND gf180mcu_fd_sc_mcu7t5v0__fillcap_4
XTAP_TAPCELL_ROW_26_312 VPWR VGND gf180mcu_fd_sc_mcu7t5v0__filltie
XFILLER_28_177 VPWR VPWR VGND VGND gf180mcu_fd_sc_mcu7t5v0__fillcap_64
XFILLER_8_527 VPWR VPWR VGND VGND gf180mcu_fd_sc_mcu7t5v0__fillcap_64
XFILLER_3_276 VPWR VPWR VGND VGND gf180mcu_fd_sc_mcu7t5v0__fillcap_4
XFILLER_35_604 VPWR VPWR VGND VGND gf180mcu_fd_sc_mcu7t5v0__fill_1
XFILLER_15_383 VPWR VPWR VGND VGND gf180mcu_fd_sc_mcu7t5v0__fill_1
XTAP_TAPCELL_ROW_32_359 VPWR VGND gf180mcu_fd_sc_mcu7t5v0__filltie
XFILLER_25_136 VPWR VPWR VGND VGND gf180mcu_fd_sc_mcu7t5v0__fillcap_4
X_641_ _641_/I uo_out[4] VPWR VPWR VGND VGND gf180mcu_fd_sc_mcu7t5v0__buf_2
XFILLER_17_604 VPWR VPWR VGND VGND gf180mcu_fd_sc_mcu7t5v0__fill_1
X_572_ _625_/Q _567_/Z _626_/Q _574_/A2 VPWR VPWR VGND VGND gf180mcu_fd_sc_mcu7t5v0__aoi21_1
XTAP_TAPCELL_ROW_37_407 VPWR VGND gf180mcu_fd_sc_mcu7t5v0__filltie
XFILLER_35_401 VPWR VPWR VGND VGND gf180mcu_fd_sc_mcu7t5v0__fillcap_8
XTAP_TAPCELL_ROW_8_154 VPWR VGND gf180mcu_fd_sc_mcu7t5v0__filltie
XFILLER_17_489 VPWR VPWR VGND VGND gf180mcu_fd_sc_mcu7t5v0__fill_1
XFILLER_17_467 VPWR VPWR VGND VGND gf180mcu_fd_sc_mcu7t5v0__fillcap_16
X_624_ _624_/D _624_/CLK _624_/Q VPWR VPWR VGND VGND gf180mcu_fd_sc_mcu7t5v0__dffq_1
X_555_ _618_/Q _550_/Z _555_/B _618_/D VPWR VPWR VGND VGND gf180mcu_fd_sc_mcu7t5v0__aoi21_1
X_486_ _489_/A1 _489_/A2 _535_/A2 VPWR VPWR VGND VGND gf180mcu_fd_sc_mcu7t5v0__nand2_2
XPHY_EDGE_ROW_32_Left_71 VPWR VGND gf180mcu_fd_sc_mcu7t5v0__endcap
XFILLER_31_492 VPWR VPWR VGND VGND gf180mcu_fd_sc_mcu7t5v0__fill_2
XTAP_TAPCELL_ROW_5_135 VPWR VGND gf180mcu_fd_sc_mcu7t5v0__filltie
X_340_ _340_/A1 _340_/A2 _426_/C VPWR VPWR VGND VGND gf180mcu_fd_sc_mcu7t5v0__or2_2
XFILLER_1_352 VPWR VPWR VGND VGND gf180mcu_fd_sc_mcu7t5v0__fillcap_64
X_538_ _613_/Q _612_/Q _578_/B _539_/B VPWR VPWR VGND VGND gf180mcu_fd_sc_mcu7t5v0__oai21_1
XTAP_TAPCELL_ROW_19_248 VPWR VGND gf180mcu_fd_sc_mcu7t5v0__filltie
X_607_ _607_/D _607_/CLK _607_/Q VPWR VPWR VGND VGND gf180mcu_fd_sc_mcu7t5v0__dffq_1
X_469_ _450_/B _469_/A2 _469_/B1 _469_/B2 _470_/B1 VPWR VPWR VGND VGND gf180mcu_fd_sc_mcu7t5v0__oai22_1
XFILLER_13_492 VPWR VPWR VGND VGND gf180mcu_fd_sc_mcu7t5v0__fillcap_64
XFILLER_36_540 VPWR VPWR VGND VGND gf180mcu_fd_sc_mcu7t5v0__fill_2
XTAP_TAPCELL_ROW_2_105 VPWR VGND gf180mcu_fd_sc_mcu7t5v0__filltie
XFILLER_23_212 VPWR VPWR VGND VGND gf180mcu_fd_sc_mcu7t5v0__fillcap_64
XTAP_TAPCELL_ROW_16_229 VPWR VGND gf180mcu_fd_sc_mcu7t5v0__filltie
XFILLER_27_562 VPWR VPWR VGND VGND gf180mcu_fd_sc_mcu7t5v0__fillcap_16
XFILLER_14_289 VPWR VPWR VGND VGND gf180mcu_fd_sc_mcu7t5v0__fill_1
X_323_ _326_/B _396_/B _420_/C VPWR VPWR VGND VGND gf180mcu_fd_sc_mcu7t5v0__nand2_2
XTAP_TAPCELL_ROW_24_295 VPWR VGND gf180mcu_fd_sc_mcu7t5v0__filltie
XTAP_TAPCELL_ROW_0_84 VPWR VGND gf180mcu_fd_sc_mcu7t5v0__filltie
XFILLER_33_521 VPWR VPWR VGND VGND gf180mcu_fd_sc_mcu7t5v0__fillcap_8
XFILLER_9_282 VPWR VPWR VGND VGND gf180mcu_fd_sc_mcu7t5v0__fillcap_64
XFILLER_18_37 VPWR VPWR VGND VGND gf180mcu_fd_sc_mcu7t5v0__fillcap_64
XFILLER_28_348 VPWR VPWR VGND VGND gf180mcu_fd_sc_mcu7t5v0__fillcap_4
Xclkload2 _602_/CLK clkload2/Z VPWR VPWR VGND VGND gf180mcu_fd_sc_mcu7t5v0__clkbuf_2
XTAP_TAPCELL_ROW_21_265 VPWR VGND gf180mcu_fd_sc_mcu7t5v0__filltie
XFILLER_34_307 VPWR VPWR VGND VGND gf180mcu_fd_sc_mcu7t5v0__fillcap_8
Xload_slew36 uio_out[5] _642_/I VPWR VPWR VGND VGND gf180mcu_fd_sc_mcu7t5v0__clkbuf_1
XFILLER_19_348 VPWR VPWR VGND VGND gf180mcu_fd_sc_mcu7t5v0__fill_2
X_306_ _604_/Q _292_/I _319_/A2 _306_/Z VPWR VPWR VGND VGND gf180mcu_fd_sc_mcu7t5v0__and3_2
XFILLER_30_535 VPWR VPWR VGND VGND gf180mcu_fd_sc_mcu7t5v0__fill_2
XFILLER_6_241 VPWR VPWR VGND VGND gf180mcu_fd_sc_mcu7t5v0__fillcap_4
XFILLER_28_101 VPWR VPWR VGND VGND gf180mcu_fd_sc_mcu7t5v0__fillcap_4
XFILLER_24_340 VPWR VPWR VGND VGND gf180mcu_fd_sc_mcu7t5v0__fillcap_8
XTAP_TAPCELL_ROW_26_313 VPWR VGND gf180mcu_fd_sc_mcu7t5v0__filltie
XFILLER_7_594 VPWR VPWR VGND VGND gf180mcu_fd_sc_mcu7t5v0__fillcap_8
XFILLER_38_410 VPWR VPWR VGND VGND gf180mcu_fd_sc_mcu7t5v0__fillcap_16
XFILLER_21_343 VPWR VPWR VGND VGND gf180mcu_fd_sc_mcu7t5v0__fillcap_4
XFILLER_21_398 VPWR VPWR VGND VGND gf180mcu_fd_sc_mcu7t5v0__fillcap_16
XPHY_EDGE_ROW_1_Right_1 VPWR VGND gf180mcu_fd_sc_mcu7t5v0__endcap
X_640_ _640_/I uo_out[3] VPWR VPWR VGND VGND gf180mcu_fd_sc_mcu7t5v0__buf_2
X_571_ _625_/Q _567_/Z _571_/B _625_/D VPWR VPWR VGND VGND gf180mcu_fd_sc_mcu7t5v0__aoi21_1
XFILLER_12_365 VPWR VPWR VGND VGND gf180mcu_fd_sc_mcu7t5v0__fillcap_4
XFILLER_12_387 VPWR VPWR VGND VGND gf180mcu_fd_sc_mcu7t5v0__fill_2
XFILLER_4_597 VPWR VPWR VGND VGND gf180mcu_fd_sc_mcu7t5v0__fillcap_8
XTAP_TAPCELL_ROW_37_408 VPWR VGND gf180mcu_fd_sc_mcu7t5v0__filltie
XFILLER_22_107 VPWR VPWR VGND VGND gf180mcu_fd_sc_mcu7t5v0__fillcap_64
XFILLER_7_72 VPWR VPWR VGND VGND gf180mcu_fd_sc_mcu7t5v0__fillcap_64
XFILLER_38_240 VPWR VPWR VGND VGND gf180mcu_fd_sc_mcu7t5v0__fillcap_16
XFILLER_26_37 VPWR VPWR VGND VGND gf180mcu_fd_sc_mcu7t5v0__fillcap_64
XFILLER_26_402 VPWR VPWR VGND VGND gf180mcu_fd_sc_mcu7t5v0__fillcap_8
XFILLER_34_490 VPWR VPWR VGND VGND gf180mcu_fd_sc_mcu7t5v0__fill_1
XTAP_TAPCELL_ROW_8_155 VPWR VGND gf180mcu_fd_sc_mcu7t5v0__filltie
XFILLER_1_556 VPWR VPWR VGND VGND gf180mcu_fd_sc_mcu7t5v0__fillcap_4
X_485_ _294_/I _295_/I _485_/ZN VPWR VPWR VGND VGND gf180mcu_fd_sc_mcu7t5v0__nor2_1
X_623_ _623_/D _624_/CLK _623_/Q VPWR VPWR VGND VGND gf180mcu_fd_sc_mcu7t5v0__dffq_1
X_554_ _618_/Q _550_/Z _578_/B _555_/B VPWR VPWR VGND VGND gf180mcu_fd_sc_mcu7t5v0__oai21_1
XFILLER_8_177 VPWR VPWR VGND VGND gf180mcu_fd_sc_mcu7t5v0__fillcap_64
XFILLER_23_405 VPWR VPWR VGND VGND gf180mcu_fd_sc_mcu7t5v0__fillcap_8
XFILLER_23_438 VPWR VPWR VGND VGND gf180mcu_fd_sc_mcu7t5v0__fill_2
XTAP_TAPCELL_ROW_5_136 VPWR VGND gf180mcu_fd_sc_mcu7t5v0__filltie
XFILLER_5_136 VPWR VPWR VGND VGND gf180mcu_fd_sc_mcu7t5v0__fillcap_4
X_468_ _460_/B _468_/A2 _468_/A3 _469_/B2 VPWR VPWR VGND VGND gf180mcu_fd_sc_mcu7t5v0__nor3_1
XFILLER_17_276 VPWR VPWR VGND VGND gf180mcu_fd_sc_mcu7t5v0__fillcap_4
XTAP_TAPCELL_ROW_19_249 VPWR VGND gf180mcu_fd_sc_mcu7t5v0__filltie
X_606_ _606_/D _607_/CLK _606_/Q VPWR VPWR VGND VGND gf180mcu_fd_sc_mcu7t5v0__dffq_1
X_537_ _612_/Q _532_/B _612_/D VPWR VPWR VGND VGND gf180mcu_fd_sc_mcu7t5v0__nor2_1
XTAP_TAPCELL_ROW_10_171 VPWR VGND gf180mcu_fd_sc_mcu7t5v0__filltie
X_399_ _326_/B _351_/Z _420_/C _399_/C _402_/A2 VPWR VPWR VGND VGND gf180mcu_fd_sc_mcu7t5v0__oai211_1
XTAP_TAPCELL_ROW_2_106 VPWR VGND gf180mcu_fd_sc_mcu7t5v0__filltie
X_322_ _606_/D _400_/A3 _332_/A1 VPWR VPWR VGND VGND gf180mcu_fd_sc_mcu7t5v0__nor2_1
XFILLER_14_279 VPWR VPWR VGND VGND gf180mcu_fd_sc_mcu7t5v0__fillcap_8
XFILLER_27_552 VPWR VPWR VGND VGND gf180mcu_fd_sc_mcu7t5v0__fillcap_8
Xfanout50 _532_/B _536_/B VPWR VPWR VGND VGND gf180mcu_fd_sc_mcu7t5v0__dlyb_1
XTAP_TAPCELL_ROW_24_296 VPWR VGND gf180mcu_fd_sc_mcu7t5v0__filltie
XTAP_TAPCELL_ROW_0_85 VPWR VGND gf180mcu_fd_sc_mcu7t5v0__filltie
XFILLER_37_349 VPWR VPWR VGND VGND gf180mcu_fd_sc_mcu7t5v0__fill_1
XFILLER_37_305 VPWR VPWR VGND VGND gf180mcu_fd_sc_mcu7t5v0__fillcap_4
Xclkbuf_3_7__f_clk clkbuf_0_clk/Z _616_/CLK VPWR VPWR VGND VGND gf180mcu_fd_sc_mcu7t5v0__clkbuf_8
XFILLER_33_533 VPWR VPWR VGND VGND gf180mcu_fd_sc_mcu7t5v0__fill_1
XFILLER_13_290 VPWR VPWR VGND VGND gf180mcu_fd_sc_mcu7t5v0__fill_2
XFILLER_36_382 VPWR VPWR VGND VGND gf180mcu_fd_sc_mcu7t5v0__fill_2
XFILLER_34_37 VPWR VPWR VGND VGND gf180mcu_fd_sc_mcu7t5v0__fillcap_64
XTAP_TAPCELL_ROW_21_266 VPWR VGND gf180mcu_fd_sc_mcu7t5v0__filltie
Xclkload3 _627_/CLK clkload3/Z VPWR VPWR VGND VGND gf180mcu_fd_sc_mcu7t5v0__clkbuf_2
XFILLER_19_327 VPWR VPWR VGND VGND gf180mcu_fd_sc_mcu7t5v0__fill_1
XFILLER_27_360 VPWR VPWR VGND VGND gf180mcu_fd_sc_mcu7t5v0__fill_2
XTAP_TAPCELL_ROW_29_333 VPWR VGND gf180mcu_fd_sc_mcu7t5v0__filltie
X_305_ _292_/I _319_/A2 _305_/B _565_/A3 VPWR VPWR VGND VGND gf180mcu_fd_sc_mcu7t5v0__aoi21_1
XFILLER_33_352 VPWR VPWR VGND VGND gf180mcu_fd_sc_mcu7t5v0__fillcap_16
XFILLER_18_371 VPWR VPWR VGND VGND gf180mcu_fd_sc_mcu7t5v0__fillcap_4
XFILLER_21_558 VPWR VPWR VGND VGND gf180mcu_fd_sc_mcu7t5v0__fill_2
XTAP_TAPCELL_ROW_34_380 VPWR VGND gf180mcu_fd_sc_mcu7t5v0__filltie
XFILLER_24_352 VPWR VPWR VGND VGND gf180mcu_fd_sc_mcu7t5v0__fill_2
XFILLER_24_363 VPWR VPWR VGND VGND gf180mcu_fd_sc_mcu7t5v0__fillcap_8
XTAP_TAPCELL_ROW_26_314 VPWR VGND gf180mcu_fd_sc_mcu7t5v0__filltie
XFILLER_3_212 VPWR VPWR VGND VGND gf180mcu_fd_sc_mcu7t5v0__fillcap_64
XFILLER_20_591 VPWR VPWR VGND VGND gf180mcu_fd_sc_mcu7t5v0__fillcap_4
XFILLER_15_352 VPWR VPWR VGND VGND gf180mcu_fd_sc_mcu7t5v0__fillcap_4
XFILLER_30_311 VPWR VPWR VGND VGND gf180mcu_fd_sc_mcu7t5v0__fillcap_4
XFILLER_30_377 VPWR VPWR VGND VGND gf180mcu_fd_sc_mcu7t5v0__fillcap_8
XFILLER_7_562 VPWR VPWR VGND VGND gf180mcu_fd_sc_mcu7t5v0__fillcap_32
XFILLER_32_2 VPWR VPWR VGND VGND gf180mcu_fd_sc_mcu7t5v0__fillcap_32
XFILLER_21_311 VPWR VPWR VGND VGND gf180mcu_fd_sc_mcu7t5v0__fillcap_4
XTAP_TAPCELL_ROW_31_350 VPWR VGND gf180mcu_fd_sc_mcu7t5v0__filltie
XFILLER_29_422 VPWR VPWR VGND VGND gf180mcu_fd_sc_mcu7t5v0__fillcap_4
X_570_ _625_/Q _567_/Z _570_/B _571_/B VPWR VPWR VGND VGND gf180mcu_fd_sc_mcu7t5v0__oai21_1
XFILLER_24_171 VPWR VPWR VGND VGND gf180mcu_fd_sc_mcu7t5v0__fillcap_4
XFILLER_4_521 VPWR VPWR VGND VGND gf180mcu_fd_sc_mcu7t5v0__fillcap_4
Xclkbuf_0_clk clk clkbuf_0_clk/Z VPWR VPWR VGND VGND gf180mcu_fd_sc_mcu7t5v0__clkbuf_8
XPHY_EDGE_ROW_15_Right_15 VPWR VGND gf180mcu_fd_sc_mcu7t5v0__endcap
XFILLER_38_274 VPWR VPWR VGND VGND gf180mcu_fd_sc_mcu7t5v0__fill_1
XPHY_EDGE_ROW_24_Right_24 VPWR VGND gf180mcu_fd_sc_mcu7t5v0__endcap
XPHY_EDGE_ROW_33_Right_33 VPWR VGND gf180mcu_fd_sc_mcu7t5v0__endcap
XTAP_TAPCELL_ROW_8_156 VPWR VGND gf180mcu_fd_sc_mcu7t5v0__filltie
X_622_ _622_/D _627_/CLK _622_/Q VPWR VPWR VGND VGND gf180mcu_fd_sc_mcu7t5v0__dffq_1
X_484_ _294_/I _489_/A2 _519_/A2 VPWR VPWR VGND VGND gf180mcu_fd_sc_mcu7t5v0__nor2_4
XFILLER_9_602 VPWR VPWR VGND VGND gf180mcu_fd_sc_mcu7t5v0__fill_2
X_553_ _618_/Q _550_/Z _556_/A2 VPWR VPWR VGND VGND gf180mcu_fd_sc_mcu7t5v0__nand2_1
XFILLER_25_480 VPWR VPWR VGND VGND gf180mcu_fd_sc_mcu7t5v0__fill_2
XFILLER_8_101 VPWR VPWR VGND VGND gf180mcu_fd_sc_mcu7t5v0__fillcap_4
XFILLER_35_244 VPWR VPWR VGND VGND gf180mcu_fd_sc_mcu7t5v0__fillcap_16
XPHY_EDGE_ROW_19_Left_58 VPWR VGND gf180mcu_fd_sc_mcu7t5v0__endcap
XFILLER_23_417 VPWR VPWR VGND VGND gf180mcu_fd_sc_mcu7t5v0__fill_2
XFILLER_14_406 VPWR VPWR VGND VGND gf180mcu_fd_sc_mcu7t5v0__fillcap_4
X_605_ _605_/D _627_/CLK _605_/Q VPWR VPWR VGND VGND gf180mcu_fd_sc_mcu7t5v0__dffq_1
X_536_ _536_/A1 _536_/A2 _536_/B _603_/D VPWR VPWR VGND VGND gf180mcu_fd_sc_mcu7t5v0__aoi21_1
X_467_ _604_/D _326_/B _467_/B _467_/C _468_/A3 VPWR VPWR VGND VGND gf180mcu_fd_sc_mcu7t5v0__aoi211_1
XFILLER_17_299 VPWR VPWR VGND VGND gf180mcu_fd_sc_mcu7t5v0__fill_1
X_398_ _399_/C _605_/D _407_/A1 VPWR VPWR VGND VGND gf180mcu_fd_sc_mcu7t5v0__nand2_1
XFILLER_32_247 VPWR VPWR VGND VGND gf180mcu_fd_sc_mcu7t5v0__fillcap_64
XTAP_TAPCELL_ROW_10_172 VPWR VGND gf180mcu_fd_sc_mcu7t5v0__filltie
XTAP_TAPCELL_ROW_2_107 VPWR VGND gf180mcu_fd_sc_mcu7t5v0__filltie
XFILLER_36_597 VPWR VPWR VGND VGND gf180mcu_fd_sc_mcu7t5v0__fillcap_8
XFILLER_2_107 VPWR VPWR VGND VGND gf180mcu_fd_sc_mcu7t5v0__fillcap_64
Xfanout51 wire52/I _532_/B VPWR VPWR VGND VGND gf180mcu_fd_sc_mcu7t5v0__buf_2
X_321_ _321_/I _368_/A2 VPWR VPWR VGND VGND gf180mcu_fd_sc_mcu7t5v0__inv_1
XFILLER_14_247 VPWR VPWR VGND VGND gf180mcu_fd_sc_mcu7t5v0__fillcap_32
XFILLER_6_457 VPWR VPWR VGND VGND gf180mcu_fd_sc_mcu7t5v0__fillcap_64
XFILLER_13_72 VPWR VPWR VGND VGND gf180mcu_fd_sc_mcu7t5v0__fillcap_64
XTAP_TAPCELL_ROW_24_297 VPWR VGND gf180mcu_fd_sc_mcu7t5v0__filltie
XTAP_TAPCELL_ROW_0_86 VPWR VGND gf180mcu_fd_sc_mcu7t5v0__filltie
XFILLER_38_91 VPWR VPWR VGND VGND gf180mcu_fd_sc_mcu7t5v0__fill_1
XFILLER_18_597 VPWR VPWR VGND VGND gf180mcu_fd_sc_mcu7t5v0__fillcap_8
X_519_ _611_/Q _519_/A2 _519_/B1 input9/Z _520_/A2 VPWR VPWR VGND VGND gf180mcu_fd_sc_mcu7t5v0__aoi22_1
XTAP_TAPCELL_ROW_15_220 VPWR VGND gf180mcu_fd_sc_mcu7t5v0__filltie
XFILLER_28_317 VPWR VPWR VGND VGND gf180mcu_fd_sc_mcu7t5v0__fill_1
XFILLER_11_206 VPWR VPWR VGND VGND gf180mcu_fd_sc_mcu7t5v0__fillcap_4
XFILLER_3_416 VPWR VPWR VGND VGND gf180mcu_fd_sc_mcu7t5v0__fillcap_4
XTAP_TAPCELL_ROW_21_267 VPWR VGND gf180mcu_fd_sc_mcu7t5v0__filltie
Xclkload4 _624_/CLK clkload4/Z VPWR VPWR VGND VGND gf180mcu_fd_sc_mcu7t5v0__clkbuf_2
Xload_slew38 uio_out[4] _641_/I VPWR VPWR VGND VGND gf180mcu_fd_sc_mcu7t5v0__clkbuf_1
XTAP_TAPCELL_ROW_29_334 VPWR VGND gf180mcu_fd_sc_mcu7t5v0__filltie
XFILLER_15_556 VPWR VPWR VGND VGND gf180mcu_fd_sc_mcu7t5v0__fillcap_4
X_304_ _377_/A1 _377_/A2 _399_/C VPWR VPWR VGND VGND gf180mcu_fd_sc_mcu7t5v0__nor2_4
XFILLER_38_604 VPWR VPWR VGND VGND gf180mcu_fd_sc_mcu7t5v0__fill_1
XFILLER_37_136 VPWR VPWR VGND VGND gf180mcu_fd_sc_mcu7t5v0__fillcap_4
XTAP_TAPCELL_ROW_26_315 VPWR VGND gf180mcu_fd_sc_mcu7t5v0__filltie
XTAP_TAPCELL_ROW_34_381 VPWR VGND gf180mcu_fd_sc_mcu7t5v0__filltie
XPHY_EDGE_ROW_7_Left_46 VPWR VGND gf180mcu_fd_sc_mcu7t5v0__endcap
XFILLER_24_375 VPWR VPWR VGND VGND gf180mcu_fd_sc_mcu7t5v0__fill_2
XFILLER_19_136 VPWR VPWR VGND VGND gf180mcu_fd_sc_mcu7t5v0__fillcap_4
XFILLER_15_331 VPWR VPWR VGND VGND gf180mcu_fd_sc_mcu7t5v0__fill_2
XFILLER_15_342 VPWR VPWR VGND VGND gf180mcu_fd_sc_mcu7t5v0__fillcap_8
XFILLER_25_2 VPWR VPWR VGND VGND gf180mcu_fd_sc_mcu7t5v0__fillcap_64
XTAP_TAPCELL_ROW_31_351 VPWR VGND gf180mcu_fd_sc_mcu7t5v0__filltie
XFILLER_29_412 VPWR VPWR VGND VGND gf180mcu_fd_sc_mcu7t5v0__fillcap_8
XFILLER_12_389 VPWR VPWR VGND VGND gf180mcu_fd_sc_mcu7t5v0__fill_1
XFILLER_21_72 VPWR VPWR VGND VGND gf180mcu_fd_sc_mcu7t5v0__fillcap_64
XFILLER_35_448 VPWR VPWR VGND VGND gf180mcu_fd_sc_mcu7t5v0__fillcap_4
XFILLER_21_142 VPWR VPWR VGND VGND gf180mcu_fd_sc_mcu7t5v0__fillcap_64
XTAP_TAPCELL_ROW_8_157 VPWR VGND gf180mcu_fd_sc_mcu7t5v0__filltie
X_621_ _621_/D _627_/CLK _621_/Q VPWR VPWR VGND VGND gf180mcu_fd_sc_mcu7t5v0__dffq_1
X_552_ _550_/Z _552_/A2 _617_/D VPWR VPWR VGND VGND gf180mcu_fd_sc_mcu7t5v0__nor2_1
X_483_ _437_/B _483_/A2 _483_/B _483_/C _586_/D VPWR VPWR VGND VGND gf180mcu_fd_sc_mcu7t5v0__oai211_1
XFILLER_0_580 VPWR VPWR VGND VGND gf180mcu_fd_sc_mcu7t5v0__fillcap_16
XFILLER_35_212 VPWR VPWR VGND VGND gf180mcu_fd_sc_mcu7t5v0__fillcap_32
XFILLER_14_418 VPWR VPWR VGND VGND gf180mcu_fd_sc_mcu7t5v0__fillcap_4
XPHY_EDGE_ROW_36_Left_75 VPWR VGND gf180mcu_fd_sc_mcu7t5v0__endcap
XFILLER_17_212 VPWR VPWR VGND VGND gf180mcu_fd_sc_mcu7t5v0__fillcap_64
XPHY_EDGE_ROW_20_Left_59 VPWR VGND gf180mcu_fd_sc_mcu7t5v0__endcap
X_604_ _604_/D _607_/CLK _604_/Q VPWR VPWR VGND VGND gf180mcu_fd_sc_mcu7t5v0__dffq_1
X_535_ _603_/Q _535_/A2 _536_/A2 VPWR VPWR VGND VGND gf180mcu_fd_sc_mcu7t5v0__nand2_1
XFILLER_9_422 VPWR VPWR VGND VGND gf180mcu_fd_sc_mcu7t5v0__fillcap_16
X_466_ _466_/A1 _466_/A2 _479_/A3 _450_/B _469_/B1 VPWR VPWR VGND VGND gf180mcu_fd_sc_mcu7t5v0__aoi22_1
X_397_ _450_/B _397_/A2 _397_/Z VPWR VPWR VGND VGND gf180mcu_fd_sc_mcu7t5v0__and2_1
XTAP_TAPCELL_ROW_10_173 VPWR VGND gf180mcu_fd_sc_mcu7t5v0__filltie
XFILLER_4_171 VPWR VPWR VGND VGND gf180mcu_fd_sc_mcu7t5v0__fillcap_4
XTAP_TAPCELL_ROW_2_108 VPWR VGND gf180mcu_fd_sc_mcu7t5v0__filltie
XFILLER_36_587 VPWR VPWR VGND VGND gf180mcu_fd_sc_mcu7t5v0__fillcap_8
XFILLER_36_532 VPWR VPWR VGND VGND gf180mcu_fd_sc_mcu7t5v0__fillcap_8
XTAP_TAPCELL_ROW_18_240 VPWR VGND gf180mcu_fd_sc_mcu7t5v0__filltie
XFILLER_27_543 VPWR VPWR VGND VGND gf180mcu_fd_sc_mcu7t5v0__fill_1
XFILLER_27_587 VPWR VPWR VGND VGND gf180mcu_fd_sc_mcu7t5v0__fillcap_16
X_320_ _532_/B _349_/B1 _349_/B2 _320_/Z VPWR VPWR VGND VGND gf180mcu_fd_sc_mcu7t5v0__or3_2
XTAP_TAPCELL_ROW_24_298 VPWR VGND gf180mcu_fd_sc_mcu7t5v0__filltie
XFILLER_10_454 VPWR VPWR VGND VGND gf180mcu_fd_sc_mcu7t5v0__fill_1
XFILLER_38_70 VPWR VPWR VGND VGND gf180mcu_fd_sc_mcu7t5v0__fillcap_8
XTAP_TAPCELL_ROW_0_87 VPWR VGND gf180mcu_fd_sc_mcu7t5v0__filltie
XFILLER_18_510 VPWR VPWR VGND VGND gf180mcu_fd_sc_mcu7t5v0__fillcap_8
X_518_ input9/Z _519_/B1 _536_/A1 VPWR VPWR VGND VGND gf180mcu_fd_sc_mcu7t5v0__nand2_1
XTAP_TAPCELL_ROW_15_221 VPWR VGND gf180mcu_fd_sc_mcu7t5v0__filltie
X_449_ _312_/Z _449_/A2 _449_/B _450_/A3 VPWR VPWR VGND VGND gf180mcu_fd_sc_mcu7t5v0__aoi21_1
XFILLER_28_307 VPWR VPWR VGND VGND gf180mcu_fd_sc_mcu7t5v0__fill_2
XFILLER_36_384 VPWR VPWR VGND VGND gf180mcu_fd_sc_mcu7t5v0__fill_1
Xclkload5 _628_/CLK clkload5/Z VPWR VPWR VGND VGND gf180mcu_fd_sc_mcu7t5v0__clkbuf_2
XFILLER_24_524 VPWR VPWR VGND VGND gf180mcu_fd_sc_mcu7t5v0__fill_1
XFILLER_24_535 VPWR VPWR VGND VGND gf180mcu_fd_sc_mcu7t5v0__fill_2
XTAP_TAPCELL_ROW_21_268 VPWR VGND gf180mcu_fd_sc_mcu7t5v0__filltie
XTAP_TAPCELL_ROW_29_335 VPWR VGND gf180mcu_fd_sc_mcu7t5v0__filltie
X_303_ _607_/Q _329_/A1 _620_/Q _377_/A2 VPWR VPWR VGND VGND gf180mcu_fd_sc_mcu7t5v0__nor3_4
XFILLER_30_527 VPWR VPWR VGND VGND gf180mcu_fd_sc_mcu7t5v0__fillcap_8
XFILLER_18_384 VPWR VPWR VGND VGND gf180mcu_fd_sc_mcu7t5v0__fill_1
XFILLER_18_395 VPWR VPWR VGND VGND gf180mcu_fd_sc_mcu7t5v0__fillcap_4
XFILLER_21_538 VPWR VPWR VGND VGND gf180mcu_fd_sc_mcu7t5v0__fillcap_16
XPHY_EDGE_ROW_23_Left_62 VPWR VGND gf180mcu_fd_sc_mcu7t5v0__endcap
XFILLER_24_354 VPWR VPWR VGND VGND gf180mcu_fd_sc_mcu7t5v0__fill_1
XTAP_TAPCELL_ROW_34_382 VPWR VGND gf180mcu_fd_sc_mcu7t5v0__filltie
XFILLER_12_527 VPWR VPWR VGND VGND gf180mcu_fd_sc_mcu7t5v0__fillcap_64
XFILLER_19_72 VPWR VPWR VGND VGND gf180mcu_fd_sc_mcu7t5v0__fillcap_64
XFILLER_34_107 VPWR VPWR VGND VGND gf180mcu_fd_sc_mcu7t5v0__fillcap_64
XFILLER_38_402 VPWR VPWR VGND VGND gf180mcu_fd_sc_mcu7t5v0__fillcap_4
XFILLER_18_2 VPWR VPWR VGND VGND gf180mcu_fd_sc_mcu7t5v0__fillcap_32
XTAP_TAPCELL_ROW_31_352 VPWR VGND gf180mcu_fd_sc_mcu7t5v0__filltie
XFILLER_0_206 VPWR VPWR VGND VGND gf180mcu_fd_sc_mcu7t5v0__fillcap_32
XFILLER_16_107 VPWR VPWR VGND VGND gf180mcu_fd_sc_mcu7t5v0__fillcap_64
XFILLER_8_317 VPWR VPWR VGND VGND gf180mcu_fd_sc_mcu7t5v0__fillcap_64
XFILLER_35_438 VPWR VPWR VGND VGND gf180mcu_fd_sc_mcu7t5v0__fill_1
XTAP_TAPCELL_ROW_36_400 VPWR VGND gf180mcu_fd_sc_mcu7t5v0__filltie
XPHY_EDGE_ROW_5_Right_5 VPWR VGND gf180mcu_fd_sc_mcu7t5v0__endcap
XTAP_TAPCELL_ROW_8_158 VPWR VGND gf180mcu_fd_sc_mcu7t5v0__filltie
X_620_ _620_/D _624_/CLK _620_/Q VPWR VPWR VGND VGND gf180mcu_fd_sc_mcu7t5v0__dffq_2
X_551_ _617_/Q _547_/Z _578_/B _552_/A2 VPWR VPWR VGND VGND gf180mcu_fd_sc_mcu7t5v0__oai21_1
XFILLER_29_276 VPWR VPWR VGND VGND gf180mcu_fd_sc_mcu7t5v0__fillcap_4
XFILLER_32_419 VPWR VPWR VGND VGND gf180mcu_fd_sc_mcu7t5v0__fill_1
XFILLER_9_604 VPWR VPWR VGND VGND gf180mcu_fd_sc_mcu7t5v0__fill_1
X_482_ _437_/B _483_/A2 _482_/A3 _483_/C VPWR VPWR VGND VGND gf180mcu_fd_sc_mcu7t5v0__nand3_1
XFILLER_23_419 VPWR VPWR VGND VGND gf180mcu_fd_sc_mcu7t5v0__fill_1
XFILLER_26_279 VPWR VPWR VGND VGND gf180mcu_fd_sc_mcu7t5v0__fillcap_16
X_534_ _534_/A1 _534_/A2 _536_/B _602_/D VPWR VPWR VGND VGND gf180mcu_fd_sc_mcu7t5v0__aoi21_1
X_603_ _603_/D _611_/CLK _603_/Q VPWR VPWR VGND VGND gf180mcu_fd_sc_mcu7t5v0__dffq_1
X_465_ _466_/A1 _466_/A2 _465_/B _469_/A2 VPWR VPWR VGND VGND gf180mcu_fd_sc_mcu7t5v0__aoi21_1
XFILLER_27_72 VPWR VPWR VGND VGND gf180mcu_fd_sc_mcu7t5v0__fillcap_64
X_396_ _399_/C _466_/A1 _396_/B _444_/B _397_/A2 VPWR VPWR VGND VGND gf180mcu_fd_sc_mcu7t5v0__oai211_1
XTAP_TAPCELL_ROW_10_174 VPWR VGND gf180mcu_fd_sc_mcu7t5v0__filltie
XFILLER_36_511 VPWR VPWR VGND VGND gf180mcu_fd_sc_mcu7t5v0__fillcap_8
XTAP_TAPCELL_ROW_2_109 VPWR VGND gf180mcu_fd_sc_mcu7t5v0__filltie
XFILLER_36_555 VPWR VPWR VGND VGND gf180mcu_fd_sc_mcu7t5v0__fillcap_32
XTAP_TAPCELL_ROW_18_241 VPWR VGND gf180mcu_fd_sc_mcu7t5v0__filltie
XFILLER_31_282 VPWR VPWR VGND VGND gf180mcu_fd_sc_mcu7t5v0__fillcap_32
Xfanout31 _565_/A3 _564_/A2 VPWR VPWR VGND VGND gf180mcu_fd_sc_mcu7t5v0__buf_2
Xfanout53 _578_/B _568_/B VPWR VPWR VGND VGND gf180mcu_fd_sc_mcu7t5v0__buf_4
XFILLER_1_142 VPWR VPWR VGND VGND gf180mcu_fd_sc_mcu7t5v0__fillcap_64
XTAP_TAPCELL_ROW_0_88 VPWR VGND gf180mcu_fd_sc_mcu7t5v0__filltie
XFILLER_18_500 VPWR VPWR VGND VGND gf180mcu_fd_sc_mcu7t5v0__fill_2
XFILLER_18_522 VPWR VPWR VGND VGND gf180mcu_fd_sc_mcu7t5v0__fill_2
XFILLER_33_558 VPWR VPWR VGND VGND gf180mcu_fd_sc_mcu7t5v0__fill_2
X_517_ _587_/Q _517_/A2 _517_/B1 _603_/Q _520_/A1 VPWR VPWR VGND VGND gf180mcu_fd_sc_mcu7t5v0__aoi22_1
X_448_ _396_/B _463_/B _460_/B _453_/A2 VPWR VPWR VGND VGND gf180mcu_fd_sc_mcu7t5v0__oai21_2
XFILLER_13_282 VPWR VPWR VGND VGND gf180mcu_fd_sc_mcu7t5v0__fillcap_8
X_379_ _360_/C _379_/A2 _379_/B1 _445_/A2 _379_/C _384_/A1 VPWR VPWR VGND VGND gf180mcu_fd_sc_mcu7t5v0__aoi221_4
XFILLER_5_492 VPWR VPWR VGND VGND gf180mcu_fd_sc_mcu7t5v0__fillcap_64
XFILLER_36_396 VPWR VPWR VGND VGND gf180mcu_fd_sc_mcu7t5v0__fillcap_4
XFILLER_36_374 VPWR VPWR VGND VGND gf180mcu_fd_sc_mcu7t5v0__fillcap_8
Xclkload6 _616_/CLK clkload6/Z VPWR VPWR VGND VGND gf180mcu_fd_sc_mcu7t5v0__clkbuf_2
XTAP_TAPCELL_ROW_21_269 VPWR VGND gf180mcu_fd_sc_mcu7t5v0__filltie
Xload_slew18 _368_/A2 _605_/D VPWR VPWR VGND VGND gf180mcu_fd_sc_mcu7t5v0__clkbuf_1
XTAP_TAPCELL_ROW_29_336 VPWR VGND gf180mcu_fd_sc_mcu7t5v0__filltie
X_302_ _319_/A2 _292_/I _624_/Q _377_/A1 VPWR VPWR VGND VGND gf180mcu_fd_sc_mcu7t5v0__aoi21_2
XFILLER_27_352 VPWR VPWR VGND VGND gf180mcu_fd_sc_mcu7t5v0__fillcap_8
XFILLER_10_241 VPWR VPWR VGND VGND gf180mcu_fd_sc_mcu7t5v0__fillcap_4
XFILLER_2_451 VPWR VPWR VGND VGND gf180mcu_fd_sc_mcu7t5v0__fillcap_4
XFILLER_1_66 VPWR VPWR VGND VGND gf180mcu_fd_sc_mcu7t5v0__fillcap_4
XFILLER_14_591 VPWR VPWR VGND VGND gf180mcu_fd_sc_mcu7t5v0__fillcap_4
XFILLER_36_171 VPWR VPWR VGND VGND gf180mcu_fd_sc_mcu7t5v0__fillcap_4
XTAP_TAPCELL_ROW_34_383 VPWR VGND gf180mcu_fd_sc_mcu7t5v0__filltie
XFILLER_15_300 VPWR VPWR VGND VGND gf180mcu_fd_sc_mcu7t5v0__fill_1
XFILLER_35_72 VPWR VPWR VGND VGND gf180mcu_fd_sc_mcu7t5v0__fillcap_64
XFILLER_15_333 VPWR VPWR VGND VGND gf180mcu_fd_sc_mcu7t5v0__fill_1
XFILLER_15_377 VPWR VPWR VGND VGND gf180mcu_fd_sc_mcu7t5v0__fillcap_4
XFILLER_11_594 VPWR VPWR VGND VGND gf180mcu_fd_sc_mcu7t5v0__fillcap_8
XFILLER_18_171 VPWR VPWR VGND VGND gf180mcu_fd_sc_mcu7t5v0__fillcap_4
XFILLER_21_303 VPWR VPWR VGND VGND gf180mcu_fd_sc_mcu7t5v0__fillcap_8
XFILLER_21_347 VPWR VPWR VGND VGND gf180mcu_fd_sc_mcu7t5v0__fill_2
XTAP_TAPCELL_ROW_31_353 VPWR VGND gf180mcu_fd_sc_mcu7t5v0__filltie
XFILLER_12_314 VPWR VPWR VGND VGND gf180mcu_fd_sc_mcu7t5v0__fill_1
XFILLER_12_369 VPWR VPWR VGND VGND gf180mcu_fd_sc_mcu7t5v0__fill_1
XFILLER_11_391 VPWR VPWR VGND VGND gf180mcu_fd_sc_mcu7t5v0__fill_2
XFILLER_30_177 VPWR VPWR VGND VGND gf180mcu_fd_sc_mcu7t5v0__fillcap_64
XFILLER_30_2 VPWR VPWR VGND VGND gf180mcu_fd_sc_mcu7t5v0__fillcap_32
XFILLER_26_439 VPWR VPWR VGND VGND gf180mcu_fd_sc_mcu7t5v0__fill_2
XTAP_TAPCELL_ROW_8_159 VPWR VGND gf180mcu_fd_sc_mcu7t5v0__filltie
X_550_ _617_/Q _547_/Z _550_/Z VPWR VPWR VGND VGND gf180mcu_fd_sc_mcu7t5v0__and2_1
X_481_ _454_/C _481_/A2 _481_/A3 _483_/B VPWR VPWR VGND VGND gf180mcu_fd_sc_mcu7t5v0__nand3_1
XFILLER_12_177 VPWR VPWR VGND VGND gf180mcu_fd_sc_mcu7t5v0__fillcap_64
XPHY_EDGE_ROW_11_Right_11 VPWR VGND gf180mcu_fd_sc_mcu7t5v0__endcap
XFILLER_4_387 VPWR VPWR VGND VGND gf180mcu_fd_sc_mcu7t5v0__fillcap_64
XPHY_EDGE_ROW_20_Right_20 VPWR VGND gf180mcu_fd_sc_mcu7t5v0__endcap
XFILLER_31_486 VPWR VPWR VGND VGND gf180mcu_fd_sc_mcu7t5v0__fillcap_4
XTAP_TAPCELL_ROW_5_129 VPWR VGND gf180mcu_fd_sc_mcu7t5v0__filltie
XFILLER_26_247 VPWR VPWR VGND VGND gf180mcu_fd_sc_mcu7t5v0__fillcap_32
X_602_ _602_/D _602_/CLK _602_/Q VPWR VPWR VGND VGND gf180mcu_fd_sc_mcu7t5v0__dffq_1
XFILLER_1_346 VPWR VPWR VGND VGND gf180mcu_fd_sc_mcu7t5v0__fillcap_4
X_533_ _602_/Q _535_/A2 _534_/A2 VPWR VPWR VGND VGND gf180mcu_fd_sc_mcu7t5v0__nand2_1
X_464_ _426_/C _464_/A2 _464_/Z VPWR VPWR VGND VGND gf180mcu_fd_sc_mcu7t5v0__and2_1
XTAP_TAPCELL_ROW_10_175 VPWR VGND gf180mcu_fd_sc_mcu7t5v0__filltie
XFILLER_13_464 VPWR VPWR VGND VGND gf180mcu_fd_sc_mcu7t5v0__fillcap_16
X_395_ _607_/D _391_/Z _395_/B _460_/B _405_/A1 VPWR VPWR VGND VGND gf180mcu_fd_sc_mcu7t5v0__oai211_2
XTAP_TAPCELL_ROW_18_242 VPWR VGND gf180mcu_fd_sc_mcu7t5v0__filltie
XFILLER_23_206 VPWR VPWR VGND VGND gf180mcu_fd_sc_mcu7t5v0__fillcap_4
Xclkbuf_3_2__f_clk clkbuf_0_clk/Z _595_/CLK VPWR VPWR VGND VGND gf180mcu_fd_sc_mcu7t5v0__clkbuf_8
XFILLER_27_578 VPWR VPWR VGND VGND gf180mcu_fd_sc_mcu7t5v0__fill_2
Xfanout54 _570_/B _578_/B VPWR VPWR VGND VGND gf180mcu_fd_sc_mcu7t5v0__buf_4
XFILLER_22_283 VPWR VPWR VGND VGND gf180mcu_fd_sc_mcu7t5v0__fill_1
XFILLER_8_2 VPWR VPWR VGND VGND gf180mcu_fd_sc_mcu7t5v0__fillcap_32
XTAP_TAPCELL_ROW_0_78 VPWR VGND gf180mcu_fd_sc_mcu7t5v0__filltie
XTAP_TAPCELL_ROW_0_89 VPWR VGND gf180mcu_fd_sc_mcu7t5v0__filltie
XFILLER_38_83 VPWR VPWR VGND VGND gf180mcu_fd_sc_mcu7t5v0__fillcap_8
XFILLER_38_61 VPWR VPWR VGND VGND gf180mcu_fd_sc_mcu7t5v0__fill_2
XFILLER_37_309 VPWR VPWR VGND VGND gf180mcu_fd_sc_mcu7t5v0__fill_1
X_516_ _516_/A1 _516_/A2 _536_/B _594_/D VPWR VPWR VGND VGND gf180mcu_fd_sc_mcu7t5v0__aoi21_1
X_447_ _308_/Z _447_/A2 _452_/B _452_/C _468_/A2 VPWR VPWR VGND VGND gf180mcu_fd_sc_mcu7t5v0__aoi211_4
X_378_ _378_/A1 _463_/B _379_/B1 VPWR VPWR VGND VGND gf180mcu_fd_sc_mcu7t5v0__nand2_1
XFILLER_9_276 VPWR VPWR VGND VGND gf180mcu_fd_sc_mcu7t5v0__fillcap_4
XFILLER_28_309 VPWR VPWR VGND VGND gf180mcu_fd_sc_mcu7t5v0__fill_1
XFILLER_32_581 VPWR VPWR VGND VGND gf180mcu_fd_sc_mcu7t5v0__fillcap_8
XTAP_TAPCELL_ROW_29_337 VPWR VGND gf180mcu_fd_sc_mcu7t5v0__filltie
X_301_ _301_/I _611_/D VPWR VPWR VGND VGND gf180mcu_fd_sc_mcu7t5v0__clkinv_1
XFILLER_33_345 VPWR VPWR VGND VGND gf180mcu_fd_sc_mcu7t5v0__fillcap_4
XFILLER_33_301 VPWR VPWR VGND VGND gf180mcu_fd_sc_mcu7t5v0__fillcap_4
XFILLER_18_375 VPWR VPWR VGND VGND gf180mcu_fd_sc_mcu7t5v0__fill_1
XTAP_TAPCELL_ROW_26_307 VPWR VGND gf180mcu_fd_sc_mcu7t5v0__filltie
XFILLER_11_562 VPWR VPWR VGND VGND gf180mcu_fd_sc_mcu7t5v0__fillcap_32
XFILLER_15_356 VPWR VPWR VGND VGND gf180mcu_fd_sc_mcu7t5v0__fill_1
XFILLER_15_367 VPWR VPWR VGND VGND gf180mcu_fd_sc_mcu7t5v0__fill_2
XFILLER_38_426 VPWR VPWR VGND VGND gf180mcu_fd_sc_mcu7t5v0__fillcap_4
XFILLER_33_142 VPWR VPWR VGND VGND gf180mcu_fd_sc_mcu7t5v0__fillcap_64
XTAP_TAPCELL_ROW_31_354 VPWR VGND gf180mcu_fd_sc_mcu7t5v0__filltie
XFILLER_37_492 VPWR VPWR VGND VGND gf180mcu_fd_sc_mcu7t5v0__fill_1
XFILLER_29_426 VPWR VPWR VGND VGND gf180mcu_fd_sc_mcu7t5v0__fill_2
XFILLER_29_437 VPWR VPWR VGND VGND gf180mcu_fd_sc_mcu7t5v0__fill_1
XFILLER_20_370 VPWR VPWR VGND VGND gf180mcu_fd_sc_mcu7t5v0__fillcap_8
XFILLER_15_142 VPWR VPWR VGND VGND gf180mcu_fd_sc_mcu7t5v0__fillcap_64
XFILLER_30_101 VPWR VPWR VGND VGND gf180mcu_fd_sc_mcu7t5v0__fillcap_4
XFILLER_7_352 VPWR VPWR VGND VGND gf180mcu_fd_sc_mcu7t5v0__fillcap_64
XFILLER_7_66 VPWR VPWR VGND VGND gf180mcu_fd_sc_mcu7t5v0__fillcap_4
XFILLER_19_470 VPWR VPWR VGND VGND gf180mcu_fd_sc_mcu7t5v0__fill_2
XFILLER_19_492 VPWR VPWR VGND VGND gf180mcu_fd_sc_mcu7t5v0__fillcap_4
XFILLER_23_2 VPWR VPWR VGND VGND gf180mcu_fd_sc_mcu7t5v0__fillcap_64
XFILLER_34_484 VPWR VPWR VGND VGND gf180mcu_fd_sc_mcu7t5v0__fillcap_4
XFILLER_29_212 VPWR VPWR VGND VGND gf180mcu_fd_sc_mcu7t5v0__fillcap_64
XFILLER_12_101 VPWR VPWR VGND VGND gf180mcu_fd_sc_mcu7t5v0__fillcap_4
XFILLER_13_602 VPWR VPWR VGND VGND gf180mcu_fd_sc_mcu7t5v0__fill_2
XFILLER_17_407 VPWR VPWR VGND VGND gf180mcu_fd_sc_mcu7t5v0__fillcap_4
XFILLER_17_418 VPWR VPWR VGND VGND gf180mcu_fd_sc_mcu7t5v0__fill_2
X_480_ _454_/C _481_/A3 _482_/A3 VPWR VPWR VGND VGND gf180mcu_fd_sc_mcu7t5v0__nand2_1
XFILLER_4_311 VPWR VPWR VGND VGND gf180mcu_fd_sc_mcu7t5v0__fillcap_4
XFILLER_16_473 VPWR VPWR VGND VGND gf180mcu_fd_sc_mcu7t5v0__fillcap_4
XFILLER_31_454 VPWR VPWR VGND VGND gf180mcu_fd_sc_mcu7t5v0__fillcap_32
XFILLER_22_454 VPWR VPWR VGND VGND gf180mcu_fd_sc_mcu7t5v0__fill_1
XFILLER_22_465 VPWR VPWR VGND VGND gf180mcu_fd_sc_mcu7t5v0__fillcap_4
X_601_ _601_/D _628_/CLK _601_/Q VPWR VPWR VGND VGND gf180mcu_fd_sc_mcu7t5v0__dffq_1
X_532_ _532_/A1 _532_/A2 _532_/B _601_/D VPWR VPWR VGND VGND gf180mcu_fd_sc_mcu7t5v0__aoi21_1
X_394_ _606_/D _351_/Z _394_/B _467_/C _395_/B VPWR VPWR VGND VGND gf180mcu_fd_sc_mcu7t5v0__oai211_1
X_463_ _607_/D _472_/A3 _463_/B _463_/C _464_/A2 VPWR VPWR VGND VGND gf180mcu_fd_sc_mcu7t5v0__oai211_1
XTAP_TAPCELL_ROW_10_176 VPWR VGND gf180mcu_fd_sc_mcu7t5v0__filltie
XFILLER_4_34 VPWR VPWR VGND VGND gf180mcu_fd_sc_mcu7t5v0__fill_1
XTAP_TAPCELL_ROW_18_243 VPWR VGND gf180mcu_fd_sc_mcu7t5v0__filltie
XTAP_TAPCELL_ROW_1_100 VPWR VGND gf180mcu_fd_sc_mcu7t5v0__filltie
Xfanout22 _452_/B _413_/B VPWR VPWR VGND VGND gf180mcu_fd_sc_mcu7t5v0__buf_2
XFILLER_10_457 VPWR VPWR VGND VGND gf180mcu_fd_sc_mcu7t5v0__fillcap_64
XFILLER_10_435 VPWR VPWR VGND VGND gf180mcu_fd_sc_mcu7t5v0__fill_1
XTAP_TAPCELL_ROW_0_79 VPWR VGND gf180mcu_fd_sc_mcu7t5v0__filltie
X_515_ input8/Z _519_/B1 _517_/A2 _586_/Q _516_/A2 VPWR VPWR VGND VGND gf180mcu_fd_sc_mcu7t5v0__aoi22_1
XFILLER_18_524 VPWR VPWR VGND VGND gf180mcu_fd_sc_mcu7t5v0__fill_1
X_446_ _446_/A1 _465_/B _445_/Z _451_/B1 VPWR VPWR VGND VGND gf180mcu_fd_sc_mcu7t5v0__nor3_1
X_377_ _377_/A1 _377_/A2 _377_/A3 _377_/A4 _463_/B VPWR VPWR VGND VGND gf180mcu_fd_sc_mcu7t5v0__or4_2
XFILLER_36_332 VPWR VPWR VGND VGND gf180mcu_fd_sc_mcu7t5v0__fillcap_4
XFILLER_36_321 VPWR VPWR VGND VGND gf180mcu_fd_sc_mcu7t5v0__fill_1
XFILLER_32_593 VPWR VPWR VGND VGND gf180mcu_fd_sc_mcu7t5v0__fill_2
XTAP_TAPCELL_ROW_29_338 VPWR VGND gf180mcu_fd_sc_mcu7t5v0__filltie
X_300_ _628_/Q _339_/A2 _300_/B _568_/B _301_/I VPWR VPWR VGND VGND gf180mcu_fd_sc_mcu7t5v0__oai211_4
XFILLER_30_519 VPWR VPWR VGND VGND gf180mcu_fd_sc_mcu7t5v0__fillcap_4
XFILLER_6_247 VPWR VPWR VGND VGND gf180mcu_fd_sc_mcu7t5v0__fillcap_64
XTAP_TAPCELL_ROW_20_260 VPWR VGND gf180mcu_fd_sc_mcu7t5v0__filltie
XFILLER_33_368 VPWR VPWR VGND VGND gf180mcu_fd_sc_mcu7t5v0__fillcap_4
XFILLER_18_354 VPWR VPWR VGND VGND gf180mcu_fd_sc_mcu7t5v0__fillcap_4
XFILLER_21_508 VPWR VPWR VGND VGND gf180mcu_fd_sc_mcu7t5v0__fill_1
X_429_ _408_/Z _474_/A2 _430_/B VPWR VPWR VGND VGND gf180mcu_fd_sc_mcu7t5v0__nand2_1
Xtt_um_r2r_dac_digital_60 uio_oe[6] VPWR VPWR VGND VGND gf180mcu_fd_sc_mcu7t5v0__tieh
Xinput1 rst_n _570_/B VPWR VPWR VGND VGND gf180mcu_fd_sc_mcu7t5v0__buf_1
XTAP_TAPCELL_ROW_26_308 VPWR VGND gf180mcu_fd_sc_mcu7t5v0__filltie
XFILLER_28_107 VPWR VPWR VGND VGND gf180mcu_fd_sc_mcu7t5v0__fillcap_64
XFILLER_24_324 VPWR VPWR VGND VGND gf180mcu_fd_sc_mcu7t5v0__fillcap_16
XFILLER_3_206 VPWR VPWR VGND VGND gf180mcu_fd_sc_mcu7t5v0__fillcap_4
XFILLER_7_556 VPWR VPWR VGND VGND gf180mcu_fd_sc_mcu7t5v0__fillcap_4
XPHY_EDGE_ROW_27_Left_66 VPWR VGND gf180mcu_fd_sc_mcu7t5v0__endcap
XFILLER_38_438 VPWR VPWR VGND VGND gf180mcu_fd_sc_mcu7t5v0__fillcap_4
XFILLER_21_349 VPWR VPWR VGND VGND gf180mcu_fd_sc_mcu7t5v0__fill_1
XTAP_TAPCELL_ROW_31_355 VPWR VGND gf180mcu_fd_sc_mcu7t5v0__filltie
XFILLER_31_603 VPWR VPWR VGND VGND gf180mcu_fd_sc_mcu7t5v0__fill_2
XFILLER_11_393 VPWR VPWR VGND VGND gf180mcu_fd_sc_mcu7t5v0__fill_1
XFILLER_34_452 VPWR VPWR VGND VGND gf180mcu_fd_sc_mcu7t5v0__fill_2
XFILLER_16_2 VPWR VPWR VGND VGND gf180mcu_fd_sc_mcu7t5v0__fillcap_32
XTAP_TAPCELL_ROW_7_150 VPWR VGND gf180mcu_fd_sc_mcu7t5v0__filltie
XFILLER_31_422 VPWR VPWR VGND VGND gf180mcu_fd_sc_mcu7t5v0__fillcap_4
XPHY_EDGE_ROW_9_Right_9 VPWR VGND gf180mcu_fd_sc_mcu7t5v0__endcap
XFILLER_34_271 VPWR VPWR VGND VGND gf180mcu_fd_sc_mcu7t5v0__fillcap_4
XPHY_EDGE_ROW_14_Left_53 VPWR VGND gf180mcu_fd_sc_mcu7t5v0__endcap
X_600_ _600_/D _628_/CLK _600_/Q VPWR VPWR VGND VGND gf180mcu_fd_sc_mcu7t5v0__dffq_1
X_531_ _601_/Q _535_/A2 _532_/A2 VPWR VPWR VGND VGND gf180mcu_fd_sc_mcu7t5v0__nand2_1
XTAP_TAPCELL_ROW_4_120 VPWR VGND gf180mcu_fd_sc_mcu7t5v0__filltie
XFILLER_13_422 VPWR VPWR VGND VGND gf180mcu_fd_sc_mcu7t5v0__fillcap_16
XFILLER_13_488 VPWR VPWR VGND VGND gf180mcu_fd_sc_mcu7t5v0__fill_2
X_462_ _466_/A2 _479_/A3 _461_/Z _460_/B _474_/C _470_/A1 VPWR VPWR VGND VGND gf180mcu_fd_sc_mcu7t5v0__oai221_2
X_393_ _326_/B _406_/B _472_/A3 VPWR VPWR VGND VGND gf180mcu_fd_sc_mcu7t5v0__nand2_1
XFILLER_25_282 VPWR VPWR VGND VGND gf180mcu_fd_sc_mcu7t5v0__fillcap_16
XTAP_TAPCELL_ROW_10_177 VPWR VGND gf180mcu_fd_sc_mcu7t5v0__filltie
XTAP_TAPCELL_ROW_18_244 VPWR VGND gf180mcu_fd_sc_mcu7t5v0__filltie
XTAP_TAPCELL_ROW_1_101 VPWR VGND gf180mcu_fd_sc_mcu7t5v0__filltie
XFILLER_22_241 VPWR VPWR VGND VGND gf180mcu_fd_sc_mcu7t5v0__fillcap_4
XFILLER_13_66 VPWR VPWR VGND VGND gf180mcu_fd_sc_mcu7t5v0__fillcap_4
XFILLER_38_52 VPWR VPWR VGND VGND gf180mcu_fd_sc_mcu7t5v0__fill_1
XFILLER_38_63 VPWR VPWR VGND VGND gf180mcu_fd_sc_mcu7t5v0__fill_1
XFILLER_38_96 VPWR VPWR VGND VGND gf180mcu_fd_sc_mcu7t5v0__fillcap_4
X_514_ _610_/Q _519_/A2 _517_/B1 _602_/Q _516_/A1 VPWR VPWR VGND VGND gf180mcu_fd_sc_mcu7t5v0__aoi22_1
XTAP_TAPCELL_ROW_15_214 VPWR VGND gf180mcu_fd_sc_mcu7t5v0__filltie
XFILLER_9_212 VPWR VPWR VGND VGND gf180mcu_fd_sc_mcu7t5v0__fillcap_64
X_445_ _467_/C _445_/A2 _460_/A2 _445_/Z VPWR VPWR VGND VGND gf180mcu_fd_sc_mcu7t5v0__and3_1
X_376_ _365_/B _610_/D _454_/C VPWR VPWR VGND VGND gf180mcu_fd_sc_mcu7t5v0__nor2_4
XFILLER_32_561 VPWR VPWR VGND VGND gf180mcu_fd_sc_mcu7t5v0__fillcap_8
XFILLER_27_344 VPWR VPWR VGND VGND gf180mcu_fd_sc_mcu7t5v0__fillcap_4
XTAP_TAPCELL_ROW_29_339 VPWR VGND gf180mcu_fd_sc_mcu7t5v0__filltie
XTAP_TAPCELL_ROW_20_261 VPWR VGND gf180mcu_fd_sc_mcu7t5v0__filltie
XFILLER_18_311 VPWR VPWR VGND VGND gf180mcu_fd_sc_mcu7t5v0__fillcap_4
XFILLER_18_399 VPWR VPWR VGND VGND gf180mcu_fd_sc_mcu7t5v0__fill_2
X_428_ _399_/C _444_/B _474_/A2 VPWR VPWR VGND VGND gf180mcu_fd_sc_mcu7t5v0__nand2_1
X_359_ _368_/C _371_/A2 _360_/C VPWR VPWR VGND VGND gf180mcu_fd_sc_mcu7t5v0__nand2_2
Xtt_um_r2r_dac_digital_61 uio_oe[7] VPWR VPWR VGND VGND gf180mcu_fd_sc_mcu7t5v0__tieh
Xinput2 ui_in[0] input2/Z VPWR VPWR VGND VGND gf180mcu_fd_sc_mcu7t5v0__buf_1
XTAP_TAPCELL_ROW_26_309 VPWR VGND gf180mcu_fd_sc_mcu7t5v0__filltie
XTAP_TAPCELL_ROW_34_375 VPWR VGND gf180mcu_fd_sc_mcu7t5v0__filltie
XFILLER_10_34 VPWR VPWR VGND VGND gf180mcu_fd_sc_mcu7t5v0__fill_1
XFILLER_20_597 VPWR VPWR VGND VGND gf180mcu_fd_sc_mcu7t5v0__fillcap_8
XPHY_EDGE_ROW_2_Left_41 VPWR VGND gf180mcu_fd_sc_mcu7t5v0__endcap
XFILLER_38_406 VPWR VPWR VGND VGND gf180mcu_fd_sc_mcu7t5v0__fill_2
XTAP_TAPCELL_ROW_31_356 VPWR VGND gf180mcu_fd_sc_mcu7t5v0__filltie
XFILLER_29_428 VPWR VPWR VGND VGND gf180mcu_fd_sc_mcu7t5v0__fill_1
XFILLER_37_483 VPWR VPWR VGND VGND gf180mcu_fd_sc_mcu7t5v0__fill_2
XFILLER_12_317 VPWR VPWR VGND VGND gf180mcu_fd_sc_mcu7t5v0__fillcap_8
XFILLER_24_177 VPWR VPWR VGND VGND gf180mcu_fd_sc_mcu7t5v0__fillcap_64
XFILLER_4_527 VPWR VPWR VGND VGND gf180mcu_fd_sc_mcu7t5v0__fillcap_64
XFILLER_21_66 VPWR VPWR VGND VGND gf180mcu_fd_sc_mcu7t5v0__fillcap_4
XFILLER_35_409 VPWR VPWR VGND VGND gf180mcu_fd_sc_mcu7t5v0__fill_2
XFILLER_11_383 VPWR VPWR VGND VGND gf180mcu_fd_sc_mcu7t5v0__fillcap_8
XFILLER_34_431 VPWR VPWR VGND VGND gf180mcu_fd_sc_mcu7t5v0__fillcap_8
XFILLER_34_420 VPWR VPWR VGND VGND gf180mcu_fd_sc_mcu7t5v0__fill_2
XFILLER_19_472 VPWR VPWR VGND VGND gf180mcu_fd_sc_mcu7t5v0__fill_1
XFILLER_21_136 VPWR VPWR VGND VGND gf180mcu_fd_sc_mcu7t5v0__fillcap_4
XFILLER_8_107 VPWR VPWR VGND VGND gf180mcu_fd_sc_mcu7t5v0__fillcap_64
XFILLER_13_604 VPWR VPWR VGND VGND gf180mcu_fd_sc_mcu7t5v0__fill_1
XTAP_TAPCELL_ROW_7_151 VPWR VGND gf180mcu_fd_sc_mcu7t5v0__filltie
XFILLER_0_596 VPWR VPWR VGND VGND gf180mcu_fd_sc_mcu7t5v0__fillcap_8
XFILLER_35_206 VPWR VPWR VGND VGND gf180mcu_fd_sc_mcu7t5v0__fillcap_4
XTAP_TAPCELL_ROW_13_197 VPWR VGND gf180mcu_fd_sc_mcu7t5v0__filltie
XFILLER_31_412 VPWR VPWR VGND VGND gf180mcu_fd_sc_mcu7t5v0__fillcap_8
XFILLER_22_401 VPWR VPWR VGND VGND gf180mcu_fd_sc_mcu7t5v0__fillcap_4
XTAP_TAPCELL_ROW_4_121 VPWR VGND gf180mcu_fd_sc_mcu7t5v0__filltie
X_530_ _530_/A1 _530_/A2 _532_/B _600_/D VPWR VPWR VGND VGND gf180mcu_fd_sc_mcu7t5v0__aoi21_1
XFILLER_17_206 VPWR VPWR VGND VGND gf180mcu_fd_sc_mcu7t5v0__fillcap_4
X_461_ _463_/B _443_/B _461_/Z VPWR VPWR VGND VGND gf180mcu_fd_sc_mcu7t5v0__and2_1
XFILLER_9_438 VPWR VPWR VGND VGND gf180mcu_fd_sc_mcu7t5v0__fill_2
XFILLER_9_416 VPWR VPWR VGND VGND gf180mcu_fd_sc_mcu7t5v0__fillcap_4
X_392_ _308_/Z _447_/A2 _452_/C _460_/A2 VPWR VPWR VGND VGND gf180mcu_fd_sc_mcu7t5v0__aoi21_4
XTAP_TAPCELL_ROW_10_178 VPWR VGND gf180mcu_fd_sc_mcu7t5v0__filltie
XPHY_EDGE_ROW_31_Left_70 VPWR VGND gf180mcu_fd_sc_mcu7t5v0__endcap
XTAP_TAPCELL_ROW_18_245 VPWR VGND gf180mcu_fd_sc_mcu7t5v0__filltie
XTAP_TAPCELL_ROW_1_102 VPWR VGND gf180mcu_fd_sc_mcu7t5v0__filltie
Xfanout24 _379_/C _460_/B VPWR VPWR VGND VGND gf180mcu_fd_sc_mcu7t5v0__buf_2
Xfanout13 _609_/D _365_/B VPWR VPWR VGND VGND gf180mcu_fd_sc_mcu7t5v0__buf_2
X_513_ input8/Z _519_/B1 _534_/A1 VPWR VPWR VGND VGND gf180mcu_fd_sc_mcu7t5v0__nand2_1
XFILLER_33_529 VPWR VPWR VGND VGND gf180mcu_fd_sc_mcu7t5v0__fillcap_4
XTAP_TAPCELL_ROW_15_215 VPWR VGND gf180mcu_fd_sc_mcu7t5v0__filltie
X_444_ _396_/B _463_/B _444_/B _465_/B VPWR VPWR VGND VGND gf180mcu_fd_sc_mcu7t5v0__oai21_1
X_375_ _375_/A1 _375_/A2 _375_/B1 _375_/B2 _388_/A2 VPWR VPWR VGND VGND gf180mcu_fd_sc_mcu7t5v0__aoi22_1
XFILLER_32_573 VPWR VPWR VGND VGND gf180mcu_fd_sc_mcu7t5v0__fill_2
XTAP_TAPCELL_ROW_20_262 VPWR VGND gf180mcu_fd_sc_mcu7t5v0__filltie
XFILLER_23_562 VPWR VPWR VGND VGND gf180mcu_fd_sc_mcu7t5v0__fillcap_4
XFILLER_6_2 VPWR VPWR VGND VGND gf180mcu_fd_sc_mcu7t5v0__fillcap_32
XFILLER_33_337 VPWR VPWR VGND VGND gf180mcu_fd_sc_mcu7t5v0__fillcap_8
X_358_ _564_/A2 _306_/Z _377_/A3 _377_/A4 _568_/B _371_/A2 VPWR VPWR VGND VGND gf180mcu_fd_sc_mcu7t5v0__oai221_2
X_427_ _427_/A1 _427_/A2 _427_/B _436_/A1 VPWR VPWR VGND VGND gf180mcu_fd_sc_mcu7t5v0__oai21_1
XFILLER_5_282 VPWR VPWR VGND VGND gf180mcu_fd_sc_mcu7t5v0__fillcap_64
XPHY_EDGE_ROW_18_Right_18 VPWR VGND gf180mcu_fd_sc_mcu7t5v0__endcap
Xinput3 ui_in[1] input3/Z VPWR VPWR VGND VGND gf180mcu_fd_sc_mcu7t5v0__buf_1
XFILLER_24_348 VPWR VPWR VGND VGND gf180mcu_fd_sc_mcu7t5v0__fillcap_4
XPHY_EDGE_ROW_27_Right_27 VPWR VGND gf180mcu_fd_sc_mcu7t5v0__endcap
XTAP_TAPCELL_ROW_34_376 VPWR VGND gf180mcu_fd_sc_mcu7t5v0__filltie
XPHY_EDGE_ROW_36_Right_36 VPWR VGND gf180mcu_fd_sc_mcu7t5v0__endcap
XFILLER_19_66 VPWR VPWR VGND VGND gf180mcu_fd_sc_mcu7t5v0__fillcap_4
XFILLER_27_142 VPWR VPWR VGND VGND gf180mcu_fd_sc_mcu7t5v0__fillcap_64
XFILLER_2_241 VPWR VPWR VGND VGND gf180mcu_fd_sc_mcu7t5v0__fillcap_4
XTAP_TAPCELL_ROW_31_357 VPWR VGND gf180mcu_fd_sc_mcu7t5v0__filltie
XFILLER_6_591 VPWR VPWR VGND VGND gf180mcu_fd_sc_mcu7t5v0__fillcap_4
XFILLER_24_101 VPWR VPWR VGND VGND gf180mcu_fd_sc_mcu7t5v0__fillcap_4
XFILLER_3_594 VPWR VPWR VGND VGND gf180mcu_fd_sc_mcu7t5v0__fillcap_8
XFILLER_34_454 VPWR VPWR VGND VGND gf180mcu_fd_sc_mcu7t5v0__fill_1
XFILLER_16_34 VPWR VPWR VGND VGND gf180mcu_fd_sc_mcu7t5v0__fill_1
XPHY_EDGE_ROW_0_Right_0 VPWR VGND gf180mcu_fd_sc_mcu7t5v0__endcap
XFILLER_25_476 VPWR VPWR VGND VGND gf180mcu_fd_sc_mcu7t5v0__fillcap_4
XTAP_TAPCELL_ROW_7_152 VPWR VGND gf180mcu_fd_sc_mcu7t5v0__filltie
XTAP_TAPCELL_ROW_13_198 VPWR VGND gf180mcu_fd_sc_mcu7t5v0__filltie
XFILLER_19_292 VPWR VPWR VGND VGND gf180mcu_fd_sc_mcu7t5v0__fill_2
XFILLER_21_2 VPWR VPWR VGND VGND gf180mcu_fd_sc_mcu7t5v0__fillcap_64
XFILLER_22_457 VPWR VPWR VGND VGND gf180mcu_fd_sc_mcu7t5v0__fillcap_8
XFILLER_22_435 VPWR VPWR VGND VGND gf180mcu_fd_sc_mcu7t5v0__fill_1
XTAP_TAPCELL_ROW_4_122 VPWR VGND gf180mcu_fd_sc_mcu7t5v0__filltie
X_460_ _452_/B _460_/A2 _460_/B _479_/A3 VPWR VPWR VGND VGND gf180mcu_fd_sc_mcu7t5v0__oai21_4
X_391_ _408_/A2 _351_/Z _452_/C _391_/Z VPWR VPWR VGND VGND gf180mcu_fd_sc_mcu7t5v0__mux2_2
XFILLER_27_66 VPWR VPWR VGND VGND gf180mcu_fd_sc_mcu7t5v0__fillcap_4
XTAP_TAPCELL_ROW_10_179 VPWR VGND gf180mcu_fd_sc_mcu7t5v0__filltie
XFILLER_4_177 VPWR VPWR VGND VGND gf180mcu_fd_sc_mcu7t5v0__fillcap_64
XFILLER_4_37 VPWR VPWR VGND VGND gf180mcu_fd_sc_mcu7t5v0__fillcap_64
X_589_ _589_/D _595_/CLK _589_/Q VPWR VPWR VGND VGND gf180mcu_fd_sc_mcu7t5v0__dffq_2
XTAP_TAPCELL_ROW_18_246 VPWR VGND gf180mcu_fd_sc_mcu7t5v0__filltie
XFILLER_31_276 VPWR VPWR VGND VGND gf180mcu_fd_sc_mcu7t5v0__fillcap_4
Xfanout14 _607_/D _467_/C VPWR VPWR VGND VGND gf180mcu_fd_sc_mcu7t5v0__buf_3
Xfanout25 _379_/C _455_/B VPWR VPWR VGND VGND gf180mcu_fd_sc_mcu7t5v0__dlyb_1
XFILLER_1_136 VPWR VPWR VGND VGND gf180mcu_fd_sc_mcu7t5v0__fillcap_4
XFILLER_18_527 VPWR VPWR VGND VGND gf180mcu_fd_sc_mcu7t5v0__fillcap_64
X_512_ _512_/A1 _512_/A2 _532_/B _593_/D VPWR VPWR VGND VGND gf180mcu_fd_sc_mcu7t5v0__aoi21_2
X_374_ _374_/A1 _374_/A2 _374_/B _426_/C _375_/B2 VPWR VPWR VGND VGND gf180mcu_fd_sc_mcu7t5v0__aoi211_1
XFILLER_13_276 VPWR VPWR VGND VGND gf180mcu_fd_sc_mcu7t5v0__fillcap_4
XTAP_TAPCELL_ROW_15_216 VPWR VGND gf180mcu_fd_sc_mcu7t5v0__filltie
X_443_ _445_/A2 _460_/A2 _443_/B _446_/A1 VPWR VPWR VGND VGND gf180mcu_fd_sc_mcu7t5v0__aoi21_1
XFILLER_26_593 VPWR VPWR VGND VGND gf180mcu_fd_sc_mcu7t5v0__fill_2
XTAP_TAPCELL_ROW_23_282 VPWR VGND gf180mcu_fd_sc_mcu7t5v0__filltie
XFILLER_5_486 VPWR VPWR VGND VGND gf180mcu_fd_sc_mcu7t5v0__fillcap_4
XFILLER_24_34 VPWR VPWR VGND VGND gf180mcu_fd_sc_mcu7t5v0__fill_1
XTAP_TAPCELL_ROW_20_263 VPWR VGND gf180mcu_fd_sc_mcu7t5v0__filltie
XFILLER_33_305 VPWR VPWR VGND VGND gf180mcu_fd_sc_mcu7t5v0__fill_1
XTAP_TAPCELL_ROW_28_330 VPWR VGND gf180mcu_fd_sc_mcu7t5v0__filltie
XFILLER_33_349 VPWR VPWR VGND VGND gf180mcu_fd_sc_mcu7t5v0__fill_1
X_357_ _564_/A2 _306_/Z _377_/A3 _377_/A4 _368_/C VPWR VPWR VGND VGND gf180mcu_fd_sc_mcu7t5v0__or4_1
X_426_ _463_/C _426_/A2 _425_/Z _360_/C _426_/C _427_/B VPWR VPWR VGND VGND gf180mcu_fd_sc_mcu7t5v0__aoi221_2
Xinput4 ui_in[2] input4/Z VPWR VPWR VGND VGND gf180mcu_fd_sc_mcu7t5v0__buf_1
XTAP_TAPCELL_ROW_34_377 VPWR VGND gf180mcu_fd_sc_mcu7t5v0__filltie
XFILLER_15_327 VPWR VPWR VGND VGND gf180mcu_fd_sc_mcu7t5v0__fillcap_4
XFILLER_35_66 VPWR VPWR VGND VGND gf180mcu_fd_sc_mcu7t5v0__fillcap_4
XTAP_TAPCELL_ROW_25_300 VPWR VGND gf180mcu_fd_sc_mcu7t5v0__filltie
XFILLER_14_382 VPWR VPWR VGND VGND gf180mcu_fd_sc_mcu7t5v0__fill_2
X_409_ _409_/A1 _408_/Z _409_/B _475_/B _410_/B VPWR VPWR VGND VGND gf180mcu_fd_sc_mcu7t5v0__oai211_1
XFILLER_37_430 VPWR VPWR VGND VGND gf180mcu_fd_sc_mcu7t5v0__fill_1
XFILLER_11_352 VPWR VPWR VGND VGND gf180mcu_fd_sc_mcu7t5v0__fillcap_8
XFILLER_3_562 VPWR VPWR VGND VGND gf180mcu_fd_sc_mcu7t5v0__fillcap_32
XFILLER_34_488 VPWR VPWR VGND VGND gf180mcu_fd_sc_mcu7t5v0__fill_2
XFILLER_34_422 VPWR VPWR VGND VGND gf180mcu_fd_sc_mcu7t5v0__fill_1
XFILLER_19_496 VPWR VPWR VGND VGND gf180mcu_fd_sc_mcu7t5v0__fill_2
XFILLER_37_282 VPWR VPWR VGND VGND gf180mcu_fd_sc_mcu7t5v0__fill_2
XFILLER_25_422 VPWR VPWR VGND VGND gf180mcu_fd_sc_mcu7t5v0__fillcap_8
XFILLER_20_171 VPWR VPWR VGND VGND gf180mcu_fd_sc_mcu7t5v0__fillcap_4
XFILLER_32_34 VPWR VPWR VGND VGND gf180mcu_fd_sc_mcu7t5v0__fill_1
XTAP_TAPCELL_ROW_7_153 VPWR VGND gf180mcu_fd_sc_mcu7t5v0__filltie
XFILLER_16_444 VPWR VPWR VGND VGND gf180mcu_fd_sc_mcu7t5v0__fill_1
XFILLER_16_477 VPWR VPWR VGND VGND gf180mcu_fd_sc_mcu7t5v0__fill_2
XFILLER_7_142 VPWR VPWR VGND VGND gf180mcu_fd_sc_mcu7t5v0__fillcap_64
XTAP_TAPCELL_ROW_13_199 VPWR VGND gf180mcu_fd_sc_mcu7t5v0__filltie
XFILLER_34_241 VPWR VPWR VGND VGND gf180mcu_fd_sc_mcu7t5v0__fillcap_4
XFILLER_14_2 VPWR VPWR VGND VGND gf180mcu_fd_sc_mcu7t5v0__fillcap_32
XFILLER_19_282 VPWR VPWR VGND VGND gf180mcu_fd_sc_mcu7t5v0__fillcap_4
XFILLER_34_263 VPWR VPWR VGND VGND gf180mcu_fd_sc_mcu7t5v0__fillcap_8
XFILLER_22_469 VPWR VPWR VGND VGND gf180mcu_fd_sc_mcu7t5v0__fill_2
XTAP_TAPCELL_ROW_4_123 VPWR VGND gf180mcu_fd_sc_mcu7t5v0__filltie
XFILLER_38_580 VPWR VPWR VGND VGND gf180mcu_fd_sc_mcu7t5v0__fillcap_16
X_390_ _301_/I _390_/A2 _387_/Z _388_/Z _580_/D VPWR VPWR VGND VGND gf180mcu_fd_sc_mcu7t5v0__aoi22_1
XFILLER_5_602 VPWR VPWR VGND VGND gf180mcu_fd_sc_mcu7t5v0__fill_2
XFILLER_4_101 VPWR VPWR VGND VGND gf180mcu_fd_sc_mcu7t5v0__fillcap_4
XFILLER_16_241 VPWR VPWR VGND VGND gf180mcu_fd_sc_mcu7t5v0__fillcap_4
XTAP_TAPCELL_ROW_18_247 VPWR VGND gf180mcu_fd_sc_mcu7t5v0__filltie
X_588_ _588_/D _611_/CLK _588_/Q VPWR VPWR VGND VGND gf180mcu_fd_sc_mcu7t5v0__dffq_2
XFILLER_8_451 VPWR VPWR VGND VGND gf180mcu_fd_sc_mcu7t5v0__fillcap_4
XPHY_EDGE_ROW_18_Left_57 VPWR VGND gf180mcu_fd_sc_mcu7t5v0__endcap
XFILLER_35_594 VPWR VPWR VGND VGND gf180mcu_fd_sc_mcu7t5v0__fillcap_8
XFILLER_27_539 VPWR VPWR VGND VGND gf180mcu_fd_sc_mcu7t5v0__fillcap_4
Xfanout48 _485_/ZN _503_/A2 VPWR VPWR VGND VGND gf180mcu_fd_sc_mcu7t5v0__buf_2
X_511_ input7/Z _519_/B1 _517_/A2 _585_/Q _512_/A2 VPWR VPWR VGND VGND gf180mcu_fd_sc_mcu7t5v0__aoi22_1
X_442_ _460_/B _441_/Z _442_/S _442_/Z VPWR VPWR VGND VGND gf180mcu_fd_sc_mcu7t5v0__mux2_2
XTAP_TAPCELL_ROW_15_217 VPWR VGND gf180mcu_fd_sc_mcu7t5v0__filltie
X_373_ _382_/A3 _371_/Z _373_/B _474_/C _374_/B VPWR VPWR VGND VGND gf180mcu_fd_sc_mcu7t5v0__aoi211_1
XTAP_TAPCELL_ROW_23_283 VPWR VGND gf180mcu_fd_sc_mcu7t5v0__filltie
XFILLER_36_336 VPWR VPWR VGND VGND gf180mcu_fd_sc_mcu7t5v0__fill_1
XFILLER_32_531 VPWR VPWR VGND VGND gf180mcu_fd_sc_mcu7t5v0__fill_1
XFILLER_17_594 VPWR VPWR VGND VGND gf180mcu_fd_sc_mcu7t5v0__fillcap_8
XFILLER_32_597 VPWR VPWR VGND VGND gf180mcu_fd_sc_mcu7t5v0__fillcap_8
XFILLER_23_597 VPWR VPWR VGND VGND gf180mcu_fd_sc_mcu7t5v0__fillcap_8
XFILLER_10_247 VPWR VPWR VGND VGND gf180mcu_fd_sc_mcu7t5v0__fillcap_64
XTAP_TAPCELL_ROW_20_264 VPWR VGND gf180mcu_fd_sc_mcu7t5v0__filltie
XFILLER_2_457 VPWR VPWR VGND VGND gf180mcu_fd_sc_mcu7t5v0__fillcap_64
XFILLER_18_358 VPWR VPWR VGND VGND gf180mcu_fd_sc_mcu7t5v0__fill_2
XTAP_TAPCELL_ROW_28_331 VPWR VGND gf180mcu_fd_sc_mcu7t5v0__filltie
X_356_ _606_/D _321_/I _449_/A2 _312_/Z _362_/A1 VPWR VPWR VGND VGND gf180mcu_fd_sc_mcu7t5v0__aoi22_1
XFILLER_14_597 VPWR VPWR VGND VGND gf180mcu_fd_sc_mcu7t5v0__fillcap_8
X_425_ _365_/B _472_/A2 _425_/Z VPWR VPWR VGND VGND gf180mcu_fd_sc_mcu7t5v0__and2_1
Xinput5 ui_in[3] input5/Z VPWR VPWR VGND VGND gf180mcu_fd_sc_mcu7t5v0__buf_1
XFILLER_36_177 VPWR VPWR VGND VGND gf180mcu_fd_sc_mcu7t5v0__fillcap_64
XTAP_TAPCELL_ROW_34_378 VPWR VGND gf180mcu_fd_sc_mcu7t5v0__filltie
XFILLER_32_383 VPWR VPWR VGND VGND gf180mcu_fd_sc_mcu7t5v0__fill_2
XFILLER_20_501 VPWR VPWR VGND VGND gf180mcu_fd_sc_mcu7t5v0__fillcap_8
XFILLER_20_523 VPWR VPWR VGND VGND gf180mcu_fd_sc_mcu7t5v0__fill_2
XFILLER_10_37 VPWR VPWR VGND VGND gf180mcu_fd_sc_mcu7t5v0__fillcap_64
XTAP_TAPCELL_ROW_25_301 VPWR VGND gf180mcu_fd_sc_mcu7t5v0__filltie
XFILLER_11_556 VPWR VPWR VGND VGND gf180mcu_fd_sc_mcu7t5v0__fillcap_4
XFILLER_33_136 VPWR VPWR VGND VGND gf180mcu_fd_sc_mcu7t5v0__fillcap_4
XFILLER_18_177 VPWR VPWR VGND VGND gf180mcu_fd_sc_mcu7t5v0__fillcap_64
X_408_ _606_/D _408_/A2 _408_/Z VPWR VPWR VGND VGND gf180mcu_fd_sc_mcu7t5v0__xor2_2
X_339_ _627_/Q _339_/A2 _578_/B _340_/A2 VPWR VPWR VGND VGND gf180mcu_fd_sc_mcu7t5v0__oai21_1
XPHY_EDGE_ROW_6_Left_45 VPWR VGND gf180mcu_fd_sc_mcu7t5v0__endcap
XFILLER_15_136 VPWR VPWR VGND VGND gf180mcu_fd_sc_mcu7t5v0__fillcap_4
XFILLER_28_464 VPWR VPWR VGND VGND gf180mcu_fd_sc_mcu7t5v0__fill_2
XFILLER_7_346 VPWR VPWR VGND VGND gf180mcu_fd_sc_mcu7t5v0__fillcap_4
XFILLER_38_206 VPWR VPWR VGND VGND gf180mcu_fd_sc_mcu7t5v0__fillcap_32
XFILLER_19_486 VPWR VPWR VGND VGND gf180mcu_fd_sc_mcu7t5v0__fillcap_4
XFILLER_34_478 VPWR VPWR VGND VGND gf180mcu_fd_sc_mcu7t5v0__fill_1
XFILLER_29_206 VPWR VPWR VGND VGND gf180mcu_fd_sc_mcu7t5v0__fillcap_4
XFILLER_37_294 VPWR VPWR VGND VGND gf180mcu_fd_sc_mcu7t5v0__fill_1
XFILLER_16_401 VPWR VPWR VGND VGND gf180mcu_fd_sc_mcu7t5v0__fill_2
XFILLER_31_426 VPWR VPWR VGND VGND gf180mcu_fd_sc_mcu7t5v0__fill_2
XFILLER_34_275 VPWR VPWR VGND VGND gf180mcu_fd_sc_mcu7t5v0__fill_1
XFILLER_19_294 VPWR VPWR VGND VGND gf180mcu_fd_sc_mcu7t5v0__fill_1
XFILLER_30_470 VPWR VPWR VGND VGND gf180mcu_fd_sc_mcu7t5v0__fillcap_16
XTAP_TAPCELL_ROW_4_124 VPWR VGND gf180mcu_fd_sc_mcu7t5v0__filltie
XFILLER_21_492 VPWR VPWR VGND VGND gf180mcu_fd_sc_mcu7t5v0__fillcap_16
X_587_ _587_/D _611_/CLK _587_/Q VPWR VPWR VGND VGND gf180mcu_fd_sc_mcu7t5v0__dffq_1
XFILLER_31_212 VPWR VPWR VGND VGND gf180mcu_fd_sc_mcu7t5v0__fillcap_64
XFILLER_27_507 VPWR VPWR VGND VGND gf180mcu_fd_sc_mcu7t5v0__fillcap_32
Xfanout49 _485_/ZN _510_/A2 VPWR VPWR VGND VGND gf180mcu_fd_sc_mcu7t5v0__dlyb_1
XFILLER_35_562 VPWR VPWR VGND VGND gf180mcu_fd_sc_mcu7t5v0__fillcap_32
Xfanout27 _320_/Z _396_/B VPWR VPWR VGND VGND gf180mcu_fd_sc_mcu7t5v0__buf_2
Xfanout16 _608_/D _444_/B VPWR VPWR VGND VGND gf180mcu_fd_sc_mcu7t5v0__buf_2
XFILLER_38_78 VPWR VPWR VGND VGND gf180mcu_fd_sc_mcu7t5v0__fill_1
X_510_ input7/Z _510_/A2 _532_/A1 VPWR VPWR VGND VGND gf180mcu_fd_sc_mcu7t5v0__nand2_1
X_441_ _444_/B _433_/B _441_/Z VPWR VPWR VGND VGND gf180mcu_fd_sc_mcu7t5v0__or2_1
XFILLER_18_518 VPWR VPWR VGND VGND gf180mcu_fd_sc_mcu7t5v0__fillcap_4
XPHY_EDGE_ROW_35_Left_74 VPWR VGND gf180mcu_fd_sc_mcu7t5v0__endcap
XFILLER_13_212 VPWR VPWR VGND VGND gf180mcu_fd_sc_mcu7t5v0__fillcap_64
X_372_ _308_/Z _452_/B _608_/D _373_/B VPWR VPWR VGND VGND gf180mcu_fd_sc_mcu7t5v0__oai21_1
XTAP_TAPCELL_ROW_15_218 VPWR VGND gf180mcu_fd_sc_mcu7t5v0__filltie
XTAP_TAPCELL_ROW_23_284 VPWR VGND gf180mcu_fd_sc_mcu7t5v0__filltie
XFILLER_5_422 VPWR VPWR VGND VGND gf180mcu_fd_sc_mcu7t5v0__fillcap_64
X_639_ _639_/I uo_out[2] VPWR VPWR VGND VGND gf180mcu_fd_sc_mcu7t5v0__buf_2
XFILLER_17_562 VPWR VPWR VGND VGND gf180mcu_fd_sc_mcu7t5v0__fillcap_32
XFILLER_27_348 VPWR VPWR VGND VGND gf180mcu_fd_sc_mcu7t5v0__fill_2
XFILLER_35_381 VPWR VPWR VGND VGND gf180mcu_fd_sc_mcu7t5v0__fillcap_4
XFILLER_14_521 VPWR VPWR VGND VGND gf180mcu_fd_sc_mcu7t5v0__fillcap_4
X_424_ _420_/C _452_/B _351_/Z _443_/B _426_/A2 VPWR VPWR VGND VGND gf180mcu_fd_sc_mcu7t5v0__oai22_1
XTAP_TAPCELL_ROW_28_332 VPWR VGND gf180mcu_fd_sc_mcu7t5v0__filltie
X_355_ _606_/D _364_/A2 _413_/B _449_/A2 VPWR VPWR VGND VGND gf180mcu_fd_sc_mcu7t5v0__oai21_2
Xinput6 ui_in[4] input6/Z VPWR VPWR VGND VGND gf180mcu_fd_sc_mcu7t5v0__buf_1
XFILLER_37_602 VPWR VPWR VGND VGND gf180mcu_fd_sc_mcu7t5v0__fill_2
XFILLER_36_101 VPWR VPWR VGND VGND gf180mcu_fd_sc_mcu7t5v0__fillcap_4
XTAP_TAPCELL_ROW_34_379 VPWR VGND gf180mcu_fd_sc_mcu7t5v0__filltie
XFILLER_17_392 VPWR VPWR VGND VGND gf180mcu_fd_sc_mcu7t5v0__fillcap_4
XTAP_TAPCELL_ROW_25_302 VPWR VGND gf180mcu_fd_sc_mcu7t5v0__filltie
Xclkbuf_3_3__f_clk clkbuf_0_clk/Z _602_/CLK VPWR VPWR VGND VGND gf180mcu_fd_sc_mcu7t5v0__clkbuf_8
XPHY_EDGE_ROW_14_Right_14 VPWR VGND gf180mcu_fd_sc_mcu7t5v0__endcap
XFILLER_23_373 VPWR VPWR VGND VGND gf180mcu_fd_sc_mcu7t5v0__fill_1
XFILLER_23_395 VPWR VPWR VGND VGND gf180mcu_fd_sc_mcu7t5v0__fill_2
XFILLER_4_2 VPWR VPWR VGND VGND gf180mcu_fd_sc_mcu7t5v0__fillcap_32
XPHY_EDGE_ROW_23_Right_23 VPWR VGND gf180mcu_fd_sc_mcu7t5v0__endcap
XFILLER_18_101 VPWR VPWR VGND VGND gf180mcu_fd_sc_mcu7t5v0__fillcap_4
XFILLER_19_602 VPWR VPWR VGND VGND gf180mcu_fd_sc_mcu7t5v0__fill_2
XPHY_EDGE_ROW_32_Right_32 VPWR VGND gf180mcu_fd_sc_mcu7t5v0__endcap
XFILLER_14_340 VPWR VPWR VGND VGND gf180mcu_fd_sc_mcu7t5v0__fill_2
XFILLER_14_351 VPWR VPWR VGND VGND gf180mcu_fd_sc_mcu7t5v0__fillcap_4
XFILLER_14_384 VPWR VPWR VGND VGND gf180mcu_fd_sc_mcu7t5v0__fill_1
X_407_ _407_/A1 _407_/A2 _410_/A2 VPWR VPWR VGND VGND gf180mcu_fd_sc_mcu7t5v0__nand2_1
X_338_ _610_/Q _560_/A2 _340_/A1 VPWR VPWR VGND VGND gf180mcu_fd_sc_mcu7t5v0__nor2_1
XFILLER_37_2 VPWR VPWR VGND VGND gf180mcu_fd_sc_mcu7t5v0__fillcap_64
XPHY_EDGE_ROW_22_Left_61 VPWR VGND gf180mcu_fd_sc_mcu7t5v0__endcap
XFILLER_37_410 VPWR VPWR VGND VGND gf180mcu_fd_sc_mcu7t5v0__fillcap_4
XFILLER_20_387 VPWR VPWR VGND VGND gf180mcu_fd_sc_mcu7t5v0__fillcap_16
XFILLER_28_454 VPWR VPWR VGND VGND gf180mcu_fd_sc_mcu7t5v0__fill_1
XFILLER_30_107 VPWR VPWR VGND VGND gf180mcu_fd_sc_mcu7t5v0__fillcap_64
XFILLER_34_457 VPWR VPWR VGND VGND gf180mcu_fd_sc_mcu7t5v0__fillcap_4
XFILLER_12_107 VPWR VPWR VGND VGND gf180mcu_fd_sc_mcu7t5v0__fillcap_64
XFILLER_16_37 VPWR VPWR VGND VGND gf180mcu_fd_sc_mcu7t5v0__fillcap_64
XFILLER_4_317 VPWR VPWR VGND VGND gf180mcu_fd_sc_mcu7t5v0__fillcap_64
XFILLER_0_512 VPWR VPWR VGND VGND gf180mcu_fd_sc_mcu7t5v0__fillcap_32
XFILLER_16_457 VPWR VPWR VGND VGND gf180mcu_fd_sc_mcu7t5v0__fillcap_8
XFILLER_28_295 VPWR VPWR VGND VGND gf180mcu_fd_sc_mcu7t5v0__fillcap_8
XFILLER_22_405 VPWR VPWR VGND VGND gf180mcu_fd_sc_mcu7t5v0__fill_1
XTAP_TAPCELL_ROW_12_190 VPWR VGND gf180mcu_fd_sc_mcu7t5v0__filltie
XPHY_EDGE_ROW_4_Right_4 VPWR VGND gf180mcu_fd_sc_mcu7t5v0__endcap
XTAP_TAPCELL_ROW_4_125 VPWR VGND gf180mcu_fd_sc_mcu7t5v0__filltie
XFILLER_13_438 VPWR VPWR VGND VGND gf180mcu_fd_sc_mcu7t5v0__fillcap_4
XFILLER_25_276 VPWR VPWR VGND VGND gf180mcu_fd_sc_mcu7t5v0__fillcap_4
XFILLER_25_298 VPWR VPWR VGND VGND gf180mcu_fd_sc_mcu7t5v0__fill_1
XFILLER_5_604 VPWR VPWR VGND VGND gf180mcu_fd_sc_mcu7t5v0__fill_1
XFILLER_0_342 VPWR VPWR VGND VGND gf180mcu_fd_sc_mcu7t5v0__fillcap_32
XFILLER_36_519 VPWR VPWR VGND VGND gf180mcu_fd_sc_mcu7t5v0__fill_1
X_586_ _586_/D _602_/CLK _586_/Q VPWR VPWR VGND VGND gf180mcu_fd_sc_mcu7t5v0__dffq_1
XFILLER_10_419 VPWR VPWR VGND VGND gf180mcu_fd_sc_mcu7t5v0__fillcap_16
Xfanout17 _368_/A2 _325_/A2 VPWR VPWR VGND VGND gf180mcu_fd_sc_mcu7t5v0__buf_4
Xfanout28 _320_/Z _321_/I VPWR VPWR VGND VGND gf180mcu_fd_sc_mcu7t5v0__buf_4
XFILLER_22_279 VPWR VPWR VGND VGND gf180mcu_fd_sc_mcu7t5v0__fillcap_4
XFILLER_38_57 VPWR VPWR VGND VGND gf180mcu_fd_sc_mcu7t5v0__fillcap_4
X_440_ _467_/B _467_/C _466_/A2 _466_/A1 _442_/S VPWR VPWR VGND VGND gf180mcu_fd_sc_mcu7t5v0__aoi22_1
X_371_ _413_/B _371_/A2 _371_/Z VPWR VPWR VGND VGND gf180mcu_fd_sc_mcu7t5v0__and2_1
XTAP_TAPCELL_ROW_15_219 VPWR VGND gf180mcu_fd_sc_mcu7t5v0__filltie
XFILLER_9_206 VPWR VPWR VGND VGND gf180mcu_fd_sc_mcu7t5v0__fillcap_4
XTAP_TAPCELL_ROW_23_285 VPWR VGND gf180mcu_fd_sc_mcu7t5v0__filltie
XFILLER_36_305 VPWR VPWR VGND VGND gf180mcu_fd_sc_mcu7t5v0__fill_2
XFILLER_0_172 VPWR VPWR VGND VGND gf180mcu_fd_sc_mcu7t5v0__fillcap_32
X_638_ _638_/I uo_out[1] VPWR VPWR VGND VGND gf180mcu_fd_sc_mcu7t5v0__buf_2
X_569_ _567_/Z _569_/A2 _624_/D VPWR VPWR VGND VGND gf180mcu_fd_sc_mcu7t5v0__nor2_1
XFILLER_5_72 VPWR VPWR VGND VGND gf180mcu_fd_sc_mcu7t5v0__fillcap_64
XFILLER_23_566 VPWR VPWR VGND VGND gf180mcu_fd_sc_mcu7t5v0__fill_2
XFILLER_24_37 VPWR VPWR VGND VGND gf180mcu_fd_sc_mcu7t5v0__fillcap_64
X_354_ _452_/C _396_/B _394_/B VPWR VPWR VGND VGND gf180mcu_fd_sc_mcu7t5v0__nand2_1
X_423_ _474_/C _423_/A2 _427_/A2 VPWR VPWR VGND VGND gf180mcu_fd_sc_mcu7t5v0__nand2_1
Xtt_um_r2r_dac_digital_55 uio_oe[1] VPWR VPWR VGND VGND gf180mcu_fd_sc_mcu7t5v0__tieh
XTAP_TAPCELL_ROW_1_95 VPWR VGND gf180mcu_fd_sc_mcu7t5v0__filltie
XFILLER_1_492 VPWR VPWR VGND VGND gf180mcu_fd_sc_mcu7t5v0__fillcap_64
Xinput7 ui_in[5] input7/Z VPWR VPWR VGND VGND gf180mcu_fd_sc_mcu7t5v0__buf_1
XFILLER_17_360 VPWR VPWR VGND VGND gf180mcu_fd_sc_mcu7t5v0__fillcap_4
XFILLER_15_319 VPWR VPWR VGND VGND gf180mcu_fd_sc_mcu7t5v0__fillcap_8
XFILLER_23_341 VPWR VPWR VGND VGND gf180mcu_fd_sc_mcu7t5v0__fill_2
XTAP_TAPCELL_ROW_25_303 VPWR VGND gf180mcu_fd_sc_mcu7t5v0__filltie
X_406_ _332_/B _606_/D _406_/B _407_/A2 VPWR VPWR VGND VGND gf180mcu_fd_sc_mcu7t5v0__oai21_1
X_337_ _474_/C _609_/D VPWR VPWR VGND VGND gf180mcu_fd_sc_mcu7t5v0__clkinv_1
XFILLER_10_591 VPWR VPWR VGND VGND gf180mcu_fd_sc_mcu7t5v0__fillcap_4
XFILLER_32_171 VPWR VPWR VGND VGND gf180mcu_fd_sc_mcu7t5v0__fillcap_4
XFILLER_19_422 VPWR VPWR VGND VGND gf180mcu_fd_sc_mcu7t5v0__fillcap_4
Xinput10 uio_in[0] _295_/I VPWR VPWR VGND VGND gf180mcu_fd_sc_mcu7t5v0__buf_1
XFILLER_14_171 VPWR VPWR VGND VGND gf180mcu_fd_sc_mcu7t5v0__fillcap_4
XFILLER_6_381 VPWR VPWR VGND VGND gf180mcu_fd_sc_mcu7t5v0__fillcap_4
XFILLER_32_37 VPWR VPWR VGND VGND gf180mcu_fd_sc_mcu7t5v0__fillcap_64
XFILLER_0_546 VPWR VPWR VGND VGND gf180mcu_fd_sc_mcu7t5v0__fillcap_32
XFILLER_16_403 VPWR VPWR VGND VGND gf180mcu_fd_sc_mcu7t5v0__fill_1
XFILLER_28_241 VPWR VPWR VGND VGND gf180mcu_fd_sc_mcu7t5v0__fillcap_4
XTAP_TAPCELL_ROW_12_191 VPWR VGND gf180mcu_fd_sc_mcu7t5v0__filltie
XFILLER_30_450 VPWR VPWR VGND VGND gf180mcu_fd_sc_mcu7t5v0__fillcap_4
XFILLER_30_461 VPWR VPWR VGND VGND gf180mcu_fd_sc_mcu7t5v0__fill_2
XTAP_TAPCELL_ROW_4_126 VPWR VGND gf180mcu_fd_sc_mcu7t5v0__filltie
XFILLER_0_376 VPWR VPWR VGND VGND gf180mcu_fd_sc_mcu7t5v0__fillcap_32
XTAP_TAPCELL_ROW_18_239 VPWR VGND gf180mcu_fd_sc_mcu7t5v0__filltie
X_585_ _585_/D _607_/CLK _585_/Q VPWR VPWR VGND VGND gf180mcu_fd_sc_mcu7t5v0__dffq_1
XFILLER_12_2 VPWR VPWR VGND VGND gf180mcu_fd_sc_mcu7t5v0__fillcap_32
Xfanout29 _315_/Z _326_/B VPWR VPWR VGND VGND gf180mcu_fd_sc_mcu7t5v0__buf_4
XFILLER_22_247 VPWR VPWR VGND VGND gf180mcu_fd_sc_mcu7t5v0__fillcap_32
XFILLER_38_36 VPWR VPWR VGND VGND gf180mcu_fd_sc_mcu7t5v0__fillcap_16
X_370_ _308_/Z _321_/I _370_/B _606_/D _382_/A3 VPWR VPWR VGND VGND gf180mcu_fd_sc_mcu7t5v0__oai211_2
XFILLER_26_597 VPWR VPWR VGND VGND gf180mcu_fd_sc_mcu7t5v0__fillcap_8
XTAP_TAPCELL_ROW_23_286 VPWR VGND gf180mcu_fd_sc_mcu7t5v0__filltie
X_637_ _637_/I uo_out[0] VPWR VPWR VGND VGND gf180mcu_fd_sc_mcu7t5v0__buf_2
XFILLER_36_317 VPWR VPWR VGND VGND gf180mcu_fd_sc_mcu7t5v0__fillcap_4
X_499_ input4/Z _510_/A2 _517_/B1 _598_/Q _500_/A2 VPWR VPWR VGND VGND gf180mcu_fd_sc_mcu7t5v0__aoi22_1
XFILLER_32_589 VPWR VPWR VGND VGND gf180mcu_fd_sc_mcu7t5v0__fillcap_4
X_568_ _624_/Q _565_/Z _568_/B _569_/A2 VPWR VPWR VGND VGND gf180mcu_fd_sc_mcu7t5v0__oai21_1
XFILLER_27_306 VPWR VPWR VGND VGND gf180mcu_fd_sc_mcu7t5v0__fillcap_4
XFILLER_23_512 VPWR VPWR VGND VGND gf180mcu_fd_sc_mcu7t5v0__fill_1
XFILLER_27_328 VPWR VPWR VGND VGND gf180mcu_fd_sc_mcu7t5v0__fillcap_16
XTAP_TAPCELL_ROW_20_256 VPWR VGND gf180mcu_fd_sc_mcu7t5v0__filltie
X_422_ _399_/C _420_/C _455_/B _422_/A4 _423_/A2 VPWR VPWR VGND VGND gf180mcu_fd_sc_mcu7t5v0__nand4_1
X_353_ _472_/A1 _353_/A2 _375_/A2 VPWR VPWR VGND VGND gf180mcu_fd_sc_mcu7t5v0__nor2_1
XFILLER_5_276 VPWR VPWR VGND VGND gf180mcu_fd_sc_mcu7t5v0__fillcap_4
Xinput8 ui_in[6] input8/Z VPWR VPWR VGND VGND gf180mcu_fd_sc_mcu7t5v0__buf_1
Xtt_um_r2r_dac_digital_56 uio_oe[2] VPWR VPWR VGND VGND gf180mcu_fd_sc_mcu7t5v0__tieh
XFILLER_37_604 VPWR VPWR VGND VGND gf180mcu_fd_sc_mcu7t5v0__fill_1
XTAP_TAPCELL_ROW_1_96 VPWR VGND gf180mcu_fd_sc_mcu7t5v0__filltie
XFILLER_32_375 VPWR VPWR VGND VGND gf180mcu_fd_sc_mcu7t5v0__fillcap_8
XFILLER_27_136 VPWR VPWR VGND VGND gf180mcu_fd_sc_mcu7t5v0__fillcap_4
XTAP_TAPCELL_ROW_33_370 VPWR VGND gf180mcu_fd_sc_mcu7t5v0__filltie
XTAP_TAPCELL_ROW_25_304 VPWR VGND gf180mcu_fd_sc_mcu7t5v0__filltie
XFILLER_19_604 VPWR VPWR VGND VGND gf180mcu_fd_sc_mcu7t5v0__fill_1
X_405_ _405_/A1 _397_/Z _405_/B1 _404_/Z _426_/C _418_/C VPWR VPWR VGND VGND gf180mcu_fd_sc_mcu7t5v0__aoi221_1
X_336_ _336_/A1 _336_/A2 _474_/C VPWR VPWR VGND VGND gf180mcu_fd_sc_mcu7t5v0__or2_2
XFILLER_20_323 VPWR VPWR VGND VGND gf180mcu_fd_sc_mcu7t5v0__fillcap_16
XFILLER_20_378 VPWR VPWR VGND VGND gf180mcu_fd_sc_mcu7t5v0__fill_2
XFILLER_11_72 VPWR VPWR VGND VGND gf180mcu_fd_sc_mcu7t5v0__fillcap_64
XFILLER_34_448 VPWR VPWR VGND VGND gf180mcu_fd_sc_mcu7t5v0__fillcap_4
XFILLER_34_404 VPWR VPWR VGND VGND gf180mcu_fd_sc_mcu7t5v0__fillcap_16
Xinput11 uio_in[1] _294_/I VPWR VPWR VGND VGND gf180mcu_fd_sc_mcu7t5v0__buf_1
X_319_ _292_/I _319_/A2 _622_/Q _349_/B2 VPWR VPWR VGND VGND gf180mcu_fd_sc_mcu7t5v0__aoi21_1
XTAP_TAPCELL_ROW_7_146 VPWR VGND gf180mcu_fd_sc_mcu7t5v0__filltie
XFILLER_11_142 VPWR VPWR VGND VGND gf180mcu_fd_sc_mcu7t5v0__fillcap_64
XFILLER_3_352 VPWR VPWR VGND VGND gf180mcu_fd_sc_mcu7t5v0__fillcap_64
XFILLER_15_492 VPWR VPWR VGND VGND gf180mcu_fd_sc_mcu7t5v0__fillcap_64
XTAP_TAPCELL_ROW_12_192 VPWR VGND gf180mcu_fd_sc_mcu7t5v0__filltie
XTAP_TAPCELL_ROW_4_127 VPWR VGND gf180mcu_fd_sc_mcu7t5v0__filltie
XFILLER_13_407 VPWR VPWR VGND VGND gf180mcu_fd_sc_mcu7t5v0__fill_1
XFILLER_25_212 VPWR VPWR VGND VGND gf180mcu_fd_sc_mcu7t5v0__fillcap_64
XFILLER_29_562 VPWR VPWR VGND VGND gf180mcu_fd_sc_mcu7t5v0__fillcap_4
X_584_ _584_/D _595_/CLK _584_/Q VPWR VPWR VGND VGND gf180mcu_fd_sc_mcu7t5v0__dffq_1
Xfanout19 _606_/D _452_/C VPWR VPWR VGND VGND gf180mcu_fd_sc_mcu7t5v0__buf_4
XTAP_TAPCELL_ROW_23_287 VPWR VGND gf180mcu_fd_sc_mcu7t5v0__filltie
XFILLER_17_532 VPWR VPWR VGND VGND gf180mcu_fd_sc_mcu7t5v0__fillcap_16
X_567_ _624_/Q _565_/Z _567_/Z VPWR VPWR VGND VGND gf180mcu_fd_sc_mcu7t5v0__and2_1
X_498_ _606_/Q _519_/A2 _517_/A2 _582_/Q _500_/A1 VPWR VPWR VGND VGND gf180mcu_fd_sc_mcu7t5v0__aoi22_1
XFILLER_8_241 VPWR VPWR VGND VGND gf180mcu_fd_sc_mcu7t5v0__fillcap_4
XTAP_TAPCELL_ROW_14_210 VPWR VGND gf180mcu_fd_sc_mcu7t5v0__filltie
XTAP_TAPCELL_ROW_20_257 VPWR VGND gf180mcu_fd_sc_mcu7t5v0__filltie
X_421_ _421_/A1 _421_/A2 _455_/B _427_/A1 VPWR VPWR VGND VGND gf180mcu_fd_sc_mcu7t5v0__aoi21_1
XTAP_TAPCELL_ROW_28_324 VPWR VGND gf180mcu_fd_sc_mcu7t5v0__filltie
X_352_ _409_/A1 _351_/Z _353_/A2 VPWR VPWR VGND VGND gf180mcu_fd_sc_mcu7t5v0__nor2_1
XFILLER_22_590 VPWR VPWR VGND VGND gf180mcu_fd_sc_mcu7t5v0__fillcap_4
XFILLER_26_395 VPWR VPWR VGND VGND gf180mcu_fd_sc_mcu7t5v0__fill_2
Xtt_um_r2r_dac_digital_57 uio_oe[3] VPWR VPWR VGND VGND gf180mcu_fd_sc_mcu7t5v0__tieh
Xinput9 ui_in[7] input9/Z VPWR VPWR VGND VGND gf180mcu_fd_sc_mcu7t5v0__buf_1
XTAP_TAPCELL_ROW_1_97 VPWR VGND gf180mcu_fd_sc_mcu7t5v0__filltie
XFILLER_17_384 VPWR VPWR VGND VGND gf180mcu_fd_sc_mcu7t5v0__fillcap_8
X_619_ _619_/D _624_/CLK _619_/Q VPWR VPWR VGND VGND gf180mcu_fd_sc_mcu7t5v0__dffq_1
XFILLER_32_387 VPWR VPWR VGND VGND gf180mcu_fd_sc_mcu7t5v0__fill_2
XFILLER_9_594 VPWR VPWR VGND VGND gf180mcu_fd_sc_mcu7t5v0__fillcap_8
XFILLER_20_527 VPWR VPWR VGND VGND gf180mcu_fd_sc_mcu7t5v0__fillcap_64
XTAP_TAPCELL_ROW_25_305 VPWR VGND gf180mcu_fd_sc_mcu7t5v0__filltie
XTAP_TAPCELL_ROW_33_371 VPWR VGND gf180mcu_fd_sc_mcu7t5v0__filltie
XFILLER_23_343 VPWR VPWR VGND VGND gf180mcu_fd_sc_mcu7t5v0__fill_1
XFILLER_23_387 VPWR VPWR VGND VGND gf180mcu_fd_sc_mcu7t5v0__fillcap_8
XFILLER_2_247 VPWR VPWR VGND VGND gf180mcu_fd_sc_mcu7t5v0__fillcap_64
X_404_ _474_/C _404_/A2 _404_/Z VPWR VPWR VGND VGND gf180mcu_fd_sc_mcu7t5v0__and2_1
X_335_ _626_/Q _339_/A2 _568_/B _336_/A2 VPWR VPWR VGND VGND gf180mcu_fd_sc_mcu7t5v0__oai21_1
XFILLER_6_597 VPWR VPWR VGND VGND gf180mcu_fd_sc_mcu7t5v0__fillcap_8
XFILLER_37_402 VPWR VPWR VGND VGND gf180mcu_fd_sc_mcu7t5v0__fillcap_8
XPHY_EDGE_ROW_10_Right_10 VPWR VGND gf180mcu_fd_sc_mcu7t5v0__endcap
XFILLER_24_107 VPWR VPWR VGND VGND gf180mcu_fd_sc_mcu7t5v0__fillcap_64
XTAP_TAPCELL_ROW_30_341 VPWR VGND gf180mcu_fd_sc_mcu7t5v0__filltie
XFILLER_28_457 VPWR VPWR VGND VGND gf180mcu_fd_sc_mcu7t5v0__fill_1
XFILLER_3_556 VPWR VPWR VGND VGND gf180mcu_fd_sc_mcu7t5v0__fillcap_4
XFILLER_2_2 VPWR VPWR VGND VGND gf180mcu_fd_sc_mcu7t5v0__fillcap_32
XPHY_EDGE_ROW_26_Left_65 VPWR VGND gf180mcu_fd_sc_mcu7t5v0__endcap
Xinput12 uio_in[2] _292_/I VPWR VPWR VGND VGND gf180mcu_fd_sc_mcu7t5v0__buf_2
XPHY_EDGE_ROW_10_Left_49 VPWR VGND gf180mcu_fd_sc_mcu7t5v0__endcap
X_318_ _605_/Q _329_/A1 _620_/Q _349_/B1 VPWR VPWR VGND VGND gf180mcu_fd_sc_mcu7t5v0__nor3_2
XFILLER_35_2 VPWR VPWR VGND VGND gf180mcu_fd_sc_mcu7t5v0__fillcap_64
XFILLER_33_471 VPWR VPWR VGND VGND gf180mcu_fd_sc_mcu7t5v0__fill_1
XTAP_TAPCELL_ROW_7_147 VPWR VGND gf180mcu_fd_sc_mcu7t5v0__filltie
XFILLER_24_471 VPWR VPWR VGND VGND gf180mcu_fd_sc_mcu7t5v0__fillcap_4
XFILLER_7_136 VPWR VPWR VGND VGND gf180mcu_fd_sc_mcu7t5v0__fillcap_4
XFILLER_19_276 VPWR VPWR VGND VGND gf180mcu_fd_sc_mcu7t5v0__fillcap_4
XFILLER_30_463 VPWR VPWR VGND VGND gf180mcu_fd_sc_mcu7t5v0__fill_1
XTAP_TAPCELL_ROW_12_193 VPWR VGND gf180mcu_fd_sc_mcu7t5v0__filltie
XTAP_TAPCELL_ROW_4_128 VPWR VGND gf180mcu_fd_sc_mcu7t5v0__filltie
XFILLER_38_596 VPWR VPWR VGND VGND gf180mcu_fd_sc_mcu7t5v0__fillcap_8
XFILLER_33_290 VPWR VPWR VGND VGND gf180mcu_fd_sc_mcu7t5v0__fillcap_4
X_583_ _583_/D _595_/CLK _583_/Q VPWR VPWR VGND VGND gf180mcu_fd_sc_mcu7t5v0__dffq_1
XFILLER_17_72 VPWR VPWR VGND VGND gf180mcu_fd_sc_mcu7t5v0__fillcap_64
XFILLER_16_279 VPWR VPWR VGND VGND gf180mcu_fd_sc_mcu7t5v0__fillcap_4
XFILLER_35_555 VPWR VPWR VGND VGND gf180mcu_fd_sc_mcu7t5v0__fillcap_4
XPHY_EDGE_ROW_8_Right_8 VPWR VGND gf180mcu_fd_sc_mcu7t5v0__endcap
XPHY_EDGE_ROW_13_Left_52 VPWR VGND gf180mcu_fd_sc_mcu7t5v0__endcap
XFILLER_26_522 VPWR VPWR VGND VGND gf180mcu_fd_sc_mcu7t5v0__fill_2
XFILLER_21_260 VPWR VPWR VGND VGND gf180mcu_fd_sc_mcu7t5v0__fillcap_8
XFILLER_21_282 VPWR VPWR VGND VGND gf180mcu_fd_sc_mcu7t5v0__fill_2
XTAP_TAPCELL_ROW_23_288 VPWR VGND gf180mcu_fd_sc_mcu7t5v0__filltie
XTAP_TAPCELL_ROW_14_211 VPWR VGND gf180mcu_fd_sc_mcu7t5v0__filltie
XFILLER_17_500 VPWR VPWR VGND VGND gf180mcu_fd_sc_mcu7t5v0__fill_2
X_566_ wire52/Z _566_/A2 _565_/Z _623_/D VPWR VPWR VGND VGND gf180mcu_fd_sc_mcu7t5v0__nor3_1
X_497_ input4/Z _510_/A2 _526_/A1 VPWR VPWR VGND VGND gf180mcu_fd_sc_mcu7t5v0__nand2_1
XFILLER_32_569 VPWR VPWR VGND VGND gf180mcu_fd_sc_mcu7t5v0__fillcap_4
XFILLER_35_385 VPWR VPWR VGND VGND gf180mcu_fd_sc_mcu7t5v0__fill_2
XTAP_TAPCELL_ROW_20_258 VPWR VGND gf180mcu_fd_sc_mcu7t5v0__filltie
X_351_ _308_/Z _310_/I _396_/B _351_/Z VPWR VPWR VGND VGND gf180mcu_fd_sc_mcu7t5v0__mux2_2
X_420_ _326_/B _351_/Z _452_/B _420_/C _421_/A2 VPWR VPWR VGND VGND gf180mcu_fd_sc_mcu7t5v0__oai211_1
XFILLER_26_341 VPWR VPWR VGND VGND gf180mcu_fd_sc_mcu7t5v0__fill_1
XFILLER_26_352 VPWR VPWR VGND VGND gf180mcu_fd_sc_mcu7t5v0__fillcap_4
XFILLER_26_374 VPWR VPWR VGND VGND gf180mcu_fd_sc_mcu7t5v0__fill_2
XTAP_TAPCELL_ROW_28_325 VPWR VGND gf180mcu_fd_sc_mcu7t5v0__filltie
XFILLER_5_212 VPWR VPWR VGND VGND gf180mcu_fd_sc_mcu7t5v0__fillcap_64
Xtt_um_r2r_dac_digital_58 uio_oe[4] VPWR VPWR VGND VGND gf180mcu_fd_sc_mcu7t5v0__tieh
XTAP_TAPCELL_ROW_1_98 VPWR VGND gf180mcu_fd_sc_mcu7t5v0__filltie
XFILLER_32_399 VPWR VPWR VGND VGND gf180mcu_fd_sc_mcu7t5v0__fill_2
XFILLER_32_311 VPWR VPWR VGND VGND gf180mcu_fd_sc_mcu7t5v0__fillcap_4
XFILLER_17_374 VPWR VPWR VGND VGND gf180mcu_fd_sc_mcu7t5v0__fillcap_4
XFILLER_17_396 VPWR VPWR VGND VGND gf180mcu_fd_sc_mcu7t5v0__fill_2
X_618_ _618_/D _624_/CLK _618_/Q VPWR VPWR VGND VGND gf180mcu_fd_sc_mcu7t5v0__dffq_1
X_549_ _547_/Z _549_/A2 _616_/D VPWR VPWR VGND VGND gf180mcu_fd_sc_mcu7t5v0__nor2_1
XFILLER_9_562 VPWR VPWR VGND VGND gf180mcu_fd_sc_mcu7t5v0__fillcap_32
XFILLER_23_311 VPWR VPWR VGND VGND gf180mcu_fd_sc_mcu7t5v0__fill_1
XTAP_TAPCELL_ROW_25_306 VPWR VGND gf180mcu_fd_sc_mcu7t5v0__filltie
XTAP_TAPCELL_ROW_33_372 VPWR VGND gf180mcu_fd_sc_mcu7t5v0__filltie
XFILLER_23_333 VPWR VPWR VGND VGND gf180mcu_fd_sc_mcu7t5v0__fillcap_8
XFILLER_14_300 VPWR VPWR VGND VGND gf180mcu_fd_sc_mcu7t5v0__fill_2
XFILLER_14_355 VPWR VPWR VGND VGND gf180mcu_fd_sc_mcu7t5v0__fill_1
X_403_ _308_/Z _413_/B _449_/A2 _360_/C _444_/B _404_/A2 VPWR VPWR VGND VGND gf180mcu_fd_sc_mcu7t5v0__oai221_1
XFILLER_25_72 VPWR VPWR VGND VGND gf180mcu_fd_sc_mcu7t5v0__fillcap_64
XFILLER_26_171 VPWR VPWR VGND VGND gf180mcu_fd_sc_mcu7t5v0__fillcap_4
X_334_ _609_/Q _560_/A2 _336_/A1 VPWR VPWR VGND VGND gf180mcu_fd_sc_mcu7t5v0__nor2_1
XFILLER_6_521 VPWR VPWR VGND VGND gf180mcu_fd_sc_mcu7t5v0__fillcap_4
XFILLER_37_436 VPWR VPWR VGND VGND gf180mcu_fd_sc_mcu7t5v0__fillcap_4
XFILLER_37_414 VPWR VPWR VGND VGND gf180mcu_fd_sc_mcu7t5v0__fill_1
XFILLER_20_358 VPWR VPWR VGND VGND gf180mcu_fd_sc_mcu7t5v0__fillcap_4
XFILLER_20_347 VPWR VPWR VGND VGND gf180mcu_fd_sc_mcu7t5v0__fill_1
XTAP_TAPCELL_ROW_30_342 VPWR VGND gf180mcu_fd_sc_mcu7t5v0__filltie
XTAP_TAPCELL_ROW_38_420 VPWR VGND gf180mcu_fd_sc_mcu7t5v0__filltie
XFILLER_36_480 VPWR VPWR VGND VGND gf180mcu_fd_sc_mcu7t5v0__fill_2
XPHY_EDGE_ROW_1_Left_40 VPWR VGND gf180mcu_fd_sc_mcu7t5v0__endcap
X_317_ _308_/Z _452_/C _466_/A1 VPWR VPWR VGND VGND gf180mcu_fd_sc_mcu7t5v0__nand2_2
XFILLER_28_2 VPWR VPWR VGND VGND gf180mcu_fd_sc_mcu7t5v0__fillcap_32
XFILLER_37_244 VPWR VPWR VGND VGND gf180mcu_fd_sc_mcu7t5v0__fillcap_4
XFILLER_18_480 VPWR VPWR VGND VGND gf180mcu_fd_sc_mcu7t5v0__fillcap_4
XFILLER_20_177 VPWR VPWR VGND VGND gf180mcu_fd_sc_mcu7t5v0__fillcap_64
XTAP_TAPCELL_ROW_7_148 VPWR VGND gf180mcu_fd_sc_mcu7t5v0__filltie
XFILLER_34_247 VPWR VPWR VGND VGND gf180mcu_fd_sc_mcu7t5v0__fillcap_16
XFILLER_15_461 VPWR VPWR VGND VGND gf180mcu_fd_sc_mcu7t5v0__fill_2
XTAP_TAPCELL_ROW_12_194 VPWR VGND gf180mcu_fd_sc_mcu7t5v0__filltie
XFILLER_30_420 VPWR VPWR VGND VGND gf180mcu_fd_sc_mcu7t5v0__fill_1
XFILLER_30_486 VPWR VPWR VGND VGND gf180mcu_fd_sc_mcu7t5v0__fillcap_4
XFILLER_4_107 VPWR VPWR VGND VGND gf180mcu_fd_sc_mcu7t5v0__fillcap_64
X_582_ _582_/D _611_/CLK _582_/Q VPWR VPWR VGND VGND gf180mcu_fd_sc_mcu7t5v0__dffq_1
XFILLER_16_247 VPWR VPWR VGND VGND gf180mcu_fd_sc_mcu7t5v0__fillcap_32
XFILLER_31_206 VPWR VPWR VGND VGND gf180mcu_fd_sc_mcu7t5v0__fillcap_4
XFILLER_33_72 VPWR VPWR VGND VGND gf180mcu_fd_sc_mcu7t5v0__fillcap_64
XFILLER_8_457 VPWR VPWR VGND VGND gf180mcu_fd_sc_mcu7t5v0__fillcap_64
XTAP_TAPCELL_ROW_17_231 VPWR VGND gf180mcu_fd_sc_mcu7t5v0__filltie
XFILLER_38_394 VPWR VPWR VGND VGND gf180mcu_fd_sc_mcu7t5v0__fillcap_8
XFILLER_13_206 VPWR VPWR VGND VGND gf180mcu_fd_sc_mcu7t5v0__fillcap_4
XFILLER_26_545 VPWR VPWR VGND VGND gf180mcu_fd_sc_mcu7t5v0__fillcap_32
XFILLER_21_272 VPWR VPWR VGND VGND gf180mcu_fd_sc_mcu7t5v0__fill_2
XTAP_TAPCELL_ROW_23_289 VPWR VGND gf180mcu_fd_sc_mcu7t5v0__filltie
XFILLER_5_416 VPWR VPWR VGND VGND gf180mcu_fd_sc_mcu7t5v0__fillcap_4
X_496_ _496_/A1 _496_/A2 _536_/B _589_/D VPWR VPWR VGND VGND gf180mcu_fd_sc_mcu7t5v0__aoi21_1
XTAP_TAPCELL_ROW_14_212 VPWR VGND gf180mcu_fd_sc_mcu7t5v0__filltie
XFILLER_17_556 VPWR VPWR VGND VGND gf180mcu_fd_sc_mcu7t5v0__fillcap_4
X_565_ _623_/Q _622_/Q _565_/A3 _565_/Z VPWR VPWR VGND VGND gf180mcu_fd_sc_mcu7t5v0__and3_1
XFILLER_10_2 VPWR VPWR VGND VGND gf180mcu_fd_sc_mcu7t5v0__fillcap_32
XTAP_TAPCELL_ROW_20_259 VPWR VGND gf180mcu_fd_sc_mcu7t5v0__filltie
XTAP_TAPCELL_ROW_36_392 VPWR VGND gf180mcu_fd_sc_mcu7t5v0__filltie
X_350_ _308_/Z _396_/B _408_/A2 VPWR VPWR VGND VGND gf180mcu_fd_sc_mcu7t5v0__nor2_1
XTAP_TAPCELL_ROW_28_326 VPWR VGND gf180mcu_fd_sc_mcu7t5v0__filltie
Xtt_um_r2r_dac_digital_59 uio_oe[5] VPWR VPWR VGND VGND gf180mcu_fd_sc_mcu7t5v0__tieh
XTAP_TAPCELL_ROW_1_99 VPWR VGND gf180mcu_fd_sc_mcu7t5v0__filltie
XFILLER_17_331 VPWR VPWR VGND VGND gf180mcu_fd_sc_mcu7t5v0__fill_2
XFILLER_17_364 VPWR VPWR VGND VGND gf180mcu_fd_sc_mcu7t5v0__fill_2
X_617_ _617_/D _624_/CLK _617_/Q VPWR VPWR VGND VGND gf180mcu_fd_sc_mcu7t5v0__dffq_1
XFILLER_32_389 VPWR VPWR VGND VGND gf180mcu_fd_sc_mcu7t5v0__fill_1
X_479_ _365_/B _610_/D _479_/A3 _483_/A2 VPWR VPWR VGND VGND gf180mcu_fd_sc_mcu7t5v0__nand3_1
X_548_ _616_/Q _543_/Z _578_/B _549_/A2 VPWR VPWR VGND VGND gf180mcu_fd_sc_mcu7t5v0__oai21_1
XTAP_TAPCELL_ROW_33_373 VPWR VGND gf180mcu_fd_sc_mcu7t5v0__filltie
X_333_ _333_/A1 _444_/B _333_/A3 _375_/A1 VPWR VPWR VGND VGND gf180mcu_fd_sc_mcu7t5v0__nand3_1
X_402_ _455_/B _402_/A2 _455_/A2 _405_/B1 VPWR VPWR VGND VGND gf180mcu_fd_sc_mcu7t5v0__nand3_1
XFILLER_1_282 VPWR VPWR VGND VGND gf180mcu_fd_sc_mcu7t5v0__fillcap_64
XTAP_TAPCELL_ROW_30_343 VPWR VGND gf180mcu_fd_sc_mcu7t5v0__filltie
XTAP_TAPCELL_ROW_38_421 VPWR VGND gf180mcu_fd_sc_mcu7t5v0__filltie
XTAP_TAPCELL_ROW_38_410 VPWR VGND gf180mcu_fd_sc_mcu7t5v0__filltie
XFILLER_11_337 VPWR VPWR VGND VGND gf180mcu_fd_sc_mcu7t5v0__fill_2
XFILLER_23_142 VPWR VPWR VGND VGND gf180mcu_fd_sc_mcu7t5v0__fillcap_64
XFILLER_19_426 VPWR VPWR VGND VGND gf180mcu_fd_sc_mcu7t5v0__fill_2
XFILLER_27_492 VPWR VPWR VGND VGND gf180mcu_fd_sc_mcu7t5v0__fillcap_4
X_316_ _326_/B _606_/D VPWR VPWR VGND VGND gf180mcu_fd_sc_mcu7t5v0__inv_4
XFILLER_10_381 VPWR VPWR VGND VGND gf180mcu_fd_sc_mcu7t5v0__fillcap_4
XFILLER_37_212 VPWR VPWR VGND VGND gf180mcu_fd_sc_mcu7t5v0__fillcap_32
XFILLER_2_591 VPWR VPWR VGND VGND gf180mcu_fd_sc_mcu7t5v0__fillcap_4
XFILLER_20_101 VPWR VPWR VGND VGND gf180mcu_fd_sc_mcu7t5v0__fillcap_4
XFILLER_21_602 VPWR VPWR VGND VGND gf180mcu_fd_sc_mcu7t5v0__fill_2
XTAP_TAPCELL_ROW_7_149 VPWR VGND gf180mcu_fd_sc_mcu7t5v0__filltie
XFILLER_19_212 VPWR VPWR VGND VGND gf180mcu_fd_sc_mcu7t5v0__fillcap_64
XFILLER_15_440 VPWR VPWR VGND VGND gf180mcu_fd_sc_mcu7t5v0__fill_2
XFILLER_6_171 VPWR VPWR VGND VGND gf180mcu_fd_sc_mcu7t5v0__fillcap_4
XTAP_TAPCELL_ROW_12_195 VPWR VGND gf180mcu_fd_sc_mcu7t5v0__filltie
XFILLER_30_454 VPWR VPWR VGND VGND gf180mcu_fd_sc_mcu7t5v0__fill_1
XFILLER_21_487 VPWR VPWR VGND VGND gf180mcu_fd_sc_mcu7t5v0__fill_2
XFILLER_29_521 VPWR VPWR VGND VGND gf180mcu_fd_sc_mcu7t5v0__fill_1
X_581_ _581_/D _602_/CLK _581_/Q VPWR VPWR VGND VGND gf180mcu_fd_sc_mcu7t5v0__dffq_1
XTAP_TAPCELL_ROW_17_232 VPWR VGND gf180mcu_fd_sc_mcu7t5v0__filltie
XFILLER_26_524 VPWR VPWR VGND VGND gf180mcu_fd_sc_mcu7t5v0__fill_1
XFILLER_26_535 VPWR VPWR VGND VGND gf180mcu_fd_sc_mcu7t5v0__fill_2
XFILLER_21_284 VPWR VPWR VGND VGND gf180mcu_fd_sc_mcu7t5v0__fill_1
XFILLER_17_502 VPWR VPWR VGND VGND gf180mcu_fd_sc_mcu7t5v0__fill_1
X_495_ _581_/Q _517_/A2 _517_/B1 _597_/Q _496_/A2 VPWR VPWR VGND VGND gf180mcu_fd_sc_mcu7t5v0__aoi22_1
XFILLER_32_527 VPWR VPWR VGND VGND gf180mcu_fd_sc_mcu7t5v0__fillcap_4
XTAP_TAPCELL_ROW_14_213 VPWR VGND gf180mcu_fd_sc_mcu7t5v0__filltie
X_564_ _622_/Q _564_/A2 _623_/Q _566_/A2 VPWR VPWR VGND VGND gf180mcu_fd_sc_mcu7t5v0__aoi21_1
XFILLER_12_295 VPWR VPWR VGND VGND gf180mcu_fd_sc_mcu7t5v0__fillcap_4
XFILLER_5_66 VPWR VPWR VGND VGND gf180mcu_fd_sc_mcu7t5v0__fillcap_4
XTAP_TAPCELL_ROW_28_327 VPWR VGND gf180mcu_fd_sc_mcu7t5v0__filltie
XTAP_TAPCELL_ROW_36_393 VPWR VGND gf180mcu_fd_sc_mcu7t5v0__filltie
XFILLER_14_527 VPWR VPWR VGND VGND gf180mcu_fd_sc_mcu7t5v0__fillcap_64
XFILLER_26_376 VPWR VPWR VGND VGND gf180mcu_fd_sc_mcu7t5v0__fill_1
XFILLER_26_387 VPWR VPWR VGND VGND gf180mcu_fd_sc_mcu7t5v0__fillcap_8
XFILLER_22_582 VPWR VPWR VGND VGND gf180mcu_fd_sc_mcu7t5v0__fillcap_8
XFILLER_1_486 VPWR VPWR VGND VGND gf180mcu_fd_sc_mcu7t5v0__fillcap_4
XFILLER_36_107 VPWR VPWR VGND VGND gf180mcu_fd_sc_mcu7t5v0__fillcap_64
XFILLER_17_343 VPWR VPWR VGND VGND gf180mcu_fd_sc_mcu7t5v0__fillcap_4
X_547_ _541_/Z _546_/Z _547_/Z VPWR VPWR VGND VGND gf180mcu_fd_sc_mcu7t5v0__and2_1
X_616_ _616_/D _616_/CLK _616_/Q VPWR VPWR VGND VGND gf180mcu_fd_sc_mcu7t5v0__dffq_1
X_478_ _611_/D _478_/A2 _478_/B _585_/D VPWR VPWR VGND VGND gf180mcu_fd_sc_mcu7t5v0__aoi21_1
XFILLER_23_357 VPWR VPWR VGND VGND gf180mcu_fd_sc_mcu7t5v0__fillcap_8
XTAP_TAPCELL_ROW_33_374 VPWR VGND gf180mcu_fd_sc_mcu7t5v0__filltie
XFILLER_14_302 VPWR VPWR VGND VGND gf180mcu_fd_sc_mcu7t5v0__fill_1
XFILLER_18_107 VPWR VPWR VGND VGND gf180mcu_fd_sc_mcu7t5v0__fillcap_64
X_401_ _401_/A1 _315_/Z _321_/I _452_/B _455_/A2 VPWR VPWR VGND VGND gf180mcu_fd_sc_mcu7t5v0__oai31_4
X_332_ _332_/A1 _449_/B _332_/B _333_/A3 VPWR VPWR VGND VGND gf180mcu_fd_sc_mcu7t5v0__oai21_1
XFILLER_2_34 VPWR VPWR VGND VGND gf180mcu_fd_sc_mcu7t5v0__fill_1
Xtt_um_r2r_dac_digital uio_oe[0] VPWR VPWR VGND VGND gf180mcu_fd_sc_mcu7t5v0__tieh
XTAP_TAPCELL_ROW_30_344 VPWR VGND gf180mcu_fd_sc_mcu7t5v0__filltie
XTAP_TAPCELL_ROW_38_422 VPWR VGND gf180mcu_fd_sc_mcu7t5v0__filltie
XTAP_TAPCELL_ROW_38_411 VPWR VGND gf180mcu_fd_sc_mcu7t5v0__filltie
XFILLER_28_438 VPWR VPWR VGND VGND gf180mcu_fd_sc_mcu7t5v0__fillcap_16
XFILLER_19_438 VPWR VPWR VGND VGND gf180mcu_fd_sc_mcu7t5v0__fill_2
X_315_ _377_/A3 _377_/A4 _315_/Z VPWR VPWR VGND VGND gf180mcu_fd_sc_mcu7t5v0__or2_2
XFILLER_33_485 VPWR VPWR VGND VGND gf180mcu_fd_sc_mcu7t5v0__fillcap_4
XFILLER_24_430 VPWR VPWR VGND VGND gf180mcu_fd_sc_mcu7t5v0__fill_1
XFILLER_28_279 VPWR VPWR VGND VGND gf180mcu_fd_sc_mcu7t5v0__fillcap_16
XFILLER_0_2 VPWR VPWR VGND VGND gf180mcu_fd_sc_mcu7t5v0__fillcap_32
XFILLER_15_485 VPWR VPWR VGND VGND gf180mcu_fd_sc_mcu7t5v0__fillcap_4
Xclkbuf_3_4__f_clk clkbuf_0_clk/Z _627_/CLK VPWR VPWR VGND VGND gf180mcu_fd_sc_mcu7t5v0__clkbuf_8
XTAP_TAPCELL_ROW_12_196 VPWR VGND gf180mcu_fd_sc_mcu7t5v0__filltie
XFILLER_33_2 VPWR VPWR VGND VGND gf180mcu_fd_sc_mcu7t5v0__fillcap_64
XFILLER_38_533 VPWR VPWR VGND VGND gf180mcu_fd_sc_mcu7t5v0__fill_1
XFILLER_33_282 VPWR VPWR VGND VGND gf180mcu_fd_sc_mcu7t5v0__fill_2
X_580_ _580_/D _607_/CLK _580_/Q VPWR VPWR VGND VGND gf180mcu_fd_sc_mcu7t5v0__dffq_1
XFILLER_29_566 VPWR VPWR VGND VGND gf180mcu_fd_sc_mcu7t5v0__fill_2
XFILLER_3_142 VPWR VPWR VGND VGND gf180mcu_fd_sc_mcu7t5v0__fillcap_64
XFILLER_35_547 VPWR VPWR VGND VGND gf180mcu_fd_sc_mcu7t5v0__fillcap_8
XTAP_TAPCELL_ROW_17_233 VPWR VGND gf180mcu_fd_sc_mcu7t5v0__filltie
XFILLER_30_241 VPWR VPWR VGND VGND gf180mcu_fd_sc_mcu7t5v0__fillcap_4
XFILLER_7_492 VPWR VPWR VGND VGND gf180mcu_fd_sc_mcu7t5v0__fillcap_64
XFILLER_26_514 VPWR VPWR VGND VGND gf180mcu_fd_sc_mcu7t5v0__fillcap_8
XPHY_EDGE_ROW_17_Right_17 VPWR VGND gf180mcu_fd_sc_mcu7t5v0__endcap
XFILLER_21_274 VPWR VPWR VGND VGND gf180mcu_fd_sc_mcu7t5v0__fill_1
XFILLER_1_602 VPWR VPWR VGND VGND gf180mcu_fd_sc_mcu7t5v0__fill_2
XPHY_EDGE_ROW_26_Right_26 VPWR VGND gf180mcu_fd_sc_mcu7t5v0__endcap
X_563_ _622_/Q _564_/A2 _563_/B _622_/D VPWR VPWR VGND VGND gf180mcu_fd_sc_mcu7t5v0__aoi21_1
XFILLER_29_330 VPWR VPWR VGND VGND gf180mcu_fd_sc_mcu7t5v0__fill_2
XPHY_EDGE_ROW_35_Right_35 VPWR VGND gf180mcu_fd_sc_mcu7t5v0__endcap
X_494_ _605_/Q _519_/A2 _519_/B1 input3/Z _496_/A1 VPWR VPWR VGND VGND gf180mcu_fd_sc_mcu7t5v0__aoi22_1
XFILLER_12_241 VPWR VPWR VGND VGND gf180mcu_fd_sc_mcu7t5v0__fillcap_4
XFILLER_4_451 VPWR VPWR VGND VGND gf180mcu_fd_sc_mcu7t5v0__fillcap_4
XTAP_TAPCELL_ROW_22_280 VPWR VGND gf180mcu_fd_sc_mcu7t5v0__filltie
XFILLER_16_591 VPWR VPWR VGND VGND gf180mcu_fd_sc_mcu7t5v0__fillcap_4
XPHY_EDGE_ROW_17_Left_56 VPWR VGND gf180mcu_fd_sc_mcu7t5v0__endcap
XTAP_TAPCELL_ROW_28_328 VPWR VGND gf180mcu_fd_sc_mcu7t5v0__filltie
XTAP_TAPCELL_ROW_36_394 VPWR VGND gf180mcu_fd_sc_mcu7t5v0__filltie
XFILLER_22_594 VPWR VPWR VGND VGND gf180mcu_fd_sc_mcu7t5v0__fill_1
X_546_ _615_/Q _616_/Q _546_/Z VPWR VPWR VGND VGND gf180mcu_fd_sc_mcu7t5v0__and2_1
X_615_ _615_/D _616_/CLK _615_/Q VPWR VPWR VGND VGND gf180mcu_fd_sc_mcu7t5v0__dffq_1
XFILLER_13_594 VPWR VPWR VGND VGND gf180mcu_fd_sc_mcu7t5v0__fillcap_8
X_477_ _438_/I _478_/A2 _478_/B VPWR VPWR VGND VGND gf180mcu_fd_sc_mcu7t5v0__nor2_1
XFILLER_14_314 VPWR VPWR VGND VGND gf180mcu_fd_sc_mcu7t5v0__fill_1
XFILLER_14_325 VPWR VPWR VGND VGND gf180mcu_fd_sc_mcu7t5v0__fillcap_4
X_400_ _308_/Z _452_/C _400_/A3 _422_/A4 VPWR VPWR VGND VGND gf180mcu_fd_sc_mcu7t5v0__nand3_1
X_331_ _379_/C _608_/D VPWR VPWR VGND VGND gf180mcu_fd_sc_mcu7t5v0__inv_3
XFILLER_10_597 VPWR VPWR VGND VGND gf180mcu_fd_sc_mcu7t5v0__fillcap_8
X_529_ _600_/Q _535_/A2 _530_/A2 VPWR VPWR VGND VGND gf180mcu_fd_sc_mcu7t5v0__nand2_1
XFILLER_20_317 VPWR VPWR VGND VGND gf180mcu_fd_sc_mcu7t5v0__fill_1
XFILLER_20_339 VPWR VPWR VGND VGND gf180mcu_fd_sc_mcu7t5v0__fillcap_8
XFILLER_32_177 VPWR VPWR VGND VGND gf180mcu_fd_sc_mcu7t5v0__fillcap_64
XTAP_TAPCELL_ROW_30_345 VPWR VGND gf180mcu_fd_sc_mcu7t5v0__filltie
XTAP_TAPCELL_ROW_38_423 VPWR VGND gf180mcu_fd_sc_mcu7t5v0__filltie
XTAP_TAPCELL_ROW_38_412 VPWR VGND gf180mcu_fd_sc_mcu7t5v0__filltie
XFILLER_11_339 VPWR VPWR VGND VGND gf180mcu_fd_sc_mcu7t5v0__fill_1
XFILLER_11_66 VPWR VPWR VGND VGND gf180mcu_fd_sc_mcu7t5v0__fillcap_4
XFILLER_14_177 VPWR VPWR VGND VGND gf180mcu_fd_sc_mcu7t5v0__fillcap_64
X_314_ _606_/Q _329_/A1 _620_/Q _568_/B _377_/A4 VPWR VPWR VGND VGND gf180mcu_fd_sc_mcu7t5v0__oai31_4
XFILLER_6_387 VPWR VPWR VGND VGND gf180mcu_fd_sc_mcu7t5v0__fillcap_64
XTAP_TAPCELL_ROW_9_170 VPWR VGND gf180mcu_fd_sc_mcu7t5v0__filltie
XFILLER_33_431 VPWR VPWR VGND VGND gf180mcu_fd_sc_mcu7t5v0__fillcap_4
XFILLER_21_604 VPWR VPWR VGND VGND gf180mcu_fd_sc_mcu7t5v0__fill_1
XFILLER_28_247 VPWR VPWR VGND VGND gf180mcu_fd_sc_mcu7t5v0__fillcap_32
XFILLER_24_475 VPWR VPWR VGND VGND gf180mcu_fd_sc_mcu7t5v0__fill_1
XFILLER_11_136 VPWR VPWR VGND VGND gf180mcu_fd_sc_mcu7t5v0__fillcap_4
XPHY_EDGE_ROW_5_Left_44 VPWR VGND gf180mcu_fd_sc_mcu7t5v0__endcap
XTAP_TAPCELL_ROW_6_140 VPWR VGND gf180mcu_fd_sc_mcu7t5v0__filltie
XFILLER_3_346 VPWR VPWR VGND VGND gf180mcu_fd_sc_mcu7t5v0__fillcap_4
XFILLER_8_34 VPWR VPWR VGND VGND gf180mcu_fd_sc_mcu7t5v0__fill_1
XFILLER_15_442 VPWR VPWR VGND VGND gf180mcu_fd_sc_mcu7t5v0__fill_1
XFILLER_38_512 VPWR VPWR VGND VGND gf180mcu_fd_sc_mcu7t5v0__fillcap_4
XFILLER_26_2 VPWR VPWR VGND VGND gf180mcu_fd_sc_mcu7t5v0__fillcap_32
XFILLER_25_206 VPWR VPWR VGND VGND gf180mcu_fd_sc_mcu7t5v0__fillcap_4
XFILLER_33_294 VPWR VPWR VGND VGND gf180mcu_fd_sc_mcu7t5v0__fill_1
XFILLER_21_489 VPWR VPWR VGND VGND gf180mcu_fd_sc_mcu7t5v0__fill_1
XFILLER_35_559 VPWR VPWR VGND VGND gf180mcu_fd_sc_mcu7t5v0__fill_1
XFILLER_35_515 VPWR VPWR VGND VGND gf180mcu_fd_sc_mcu7t5v0__fill_2
XTAP_TAPCELL_ROW_17_234 VPWR VGND gf180mcu_fd_sc_mcu7t5v0__filltie
X_493_ input3/Z _519_/B1 _524_/A1 VPWR VPWR VGND VGND gf180mcu_fd_sc_mcu7t5v0__nand2_1
XFILLER_17_548 VPWR VPWR VGND VGND gf180mcu_fd_sc_mcu7t5v0__fillcap_8
X_562_ _622_/Q _564_/A2 _568_/B _563_/B VPWR VPWR VGND VGND gf180mcu_fd_sc_mcu7t5v0__oai21_1
XTAP_TAPCELL_ROW_22_281 VPWR VGND gf180mcu_fd_sc_mcu7t5v0__filltie
XFILLER_31_562 VPWR VPWR VGND VGND gf180mcu_fd_sc_mcu7t5v0__fillcap_4
XFILLER_31_595 VPWR VPWR VGND VGND gf180mcu_fd_sc_mcu7t5v0__fillcap_8
XFILLER_38_172 VPWR VPWR VGND VGND gf180mcu_fd_sc_mcu7t5v0__fillcap_32
XTAP_TAPCELL_ROW_28_329 VPWR VGND gf180mcu_fd_sc_mcu7t5v0__filltie
XTAP_TAPCELL_ROW_36_395 VPWR VGND gf180mcu_fd_sc_mcu7t5v0__filltie
XFILLER_1_422 VPWR VPWR VGND VGND gf180mcu_fd_sc_mcu7t5v0__fillcap_64
XPHY_EDGE_ROW_34_Left_73 VPWR VGND gf180mcu_fd_sc_mcu7t5v0__endcap
X_545_ _543_/Z _545_/A2 _615_/D VPWR VPWR VGND VGND gf180mcu_fd_sc_mcu7t5v0__nor2_1
XFILLER_13_562 VPWR VPWR VGND VGND gf180mcu_fd_sc_mcu7t5v0__fillcap_32
XFILLER_17_378 VPWR VPWR VGND VGND gf180mcu_fd_sc_mcu7t5v0__fill_1
X_476_ _476_/A1 _476_/A2 _476_/B _478_/A2 VPWR VPWR VGND VGND gf180mcu_fd_sc_mcu7t5v0__aoi21_1
X_614_ _614_/D _616_/CLK _614_/Q VPWR VPWR VGND VGND gf180mcu_fd_sc_mcu7t5v0__dffq_1
XFILLER_35_142 VPWR VPWR VGND VGND gf180mcu_fd_sc_mcu7t5v0__fillcap_64
XFILLER_31_381 VPWR VPWR VGND VGND gf180mcu_fd_sc_mcu7t5v0__fillcap_8
X_330_ _568_/B _328_/Z _330_/A3 _379_/C VPWR VPWR VGND VGND gf180mcu_fd_sc_mcu7t5v0__nand3_2
XFILLER_10_521 VPWR VPWR VGND VGND gf180mcu_fd_sc_mcu7t5v0__fillcap_4
XFILLER_33_602 VPWR VPWR VGND VGND gf180mcu_fd_sc_mcu7t5v0__fill_2
XFILLER_17_142 VPWR VPWR VGND VGND gf180mcu_fd_sc_mcu7t5v0__fillcap_64
X_528_ _528_/A1 _528_/A2 _532_/B _599_/D VPWR VPWR VGND VGND gf180mcu_fd_sc_mcu7t5v0__aoi21_1
XFILLER_9_352 VPWR VPWR VGND VGND gf180mcu_fd_sc_mcu7t5v0__fillcap_64
XFILLER_20_307 VPWR VPWR VGND VGND gf180mcu_fd_sc_mcu7t5v0__fillcap_8
X_459_ _481_/A2 _437_/B _459_/S _583_/D VPWR VPWR VGND VGND gf180mcu_fd_sc_mcu7t5v0__mux2_2
XTAP_TAPCELL_ROW_30_346 VPWR VGND gf180mcu_fd_sc_mcu7t5v0__filltie
XFILLER_32_101 VPWR VPWR VGND VGND gf180mcu_fd_sc_mcu7t5v0__fillcap_4
XTAP_TAPCELL_ROW_38_424 VPWR VGND gf180mcu_fd_sc_mcu7t5v0__filltie
XTAP_TAPCELL_ROW_38_413 VPWR VGND gf180mcu_fd_sc_mcu7t5v0__filltie
XFILLER_15_602 VPWR VPWR VGND VGND gf180mcu_fd_sc_mcu7t5v0__fill_2
XFILLER_27_451 VPWR VPWR VGND VGND gf180mcu_fd_sc_mcu7t5v0__fillcap_4
XFILLER_14_101 VPWR VPWR VGND VGND gf180mcu_fd_sc_mcu7t5v0__fillcap_4
X_313_ _292_/I _319_/A2 _623_/Q _377_/A3 VPWR VPWR VGND VGND gf180mcu_fd_sc_mcu7t5v0__aoi21_2
XFILLER_27_484 VPWR VPWR VGND VGND gf180mcu_fd_sc_mcu7t5v0__fillcap_4
XFILLER_6_311 VPWR VPWR VGND VGND gf180mcu_fd_sc_mcu7t5v0__fillcap_4
XFILLER_37_248 VPWR VPWR VGND VGND gf180mcu_fd_sc_mcu7t5v0__fill_1
XPHY_EDGE_ROW_21_Left_60 VPWR VGND gf180mcu_fd_sc_mcu7t5v0__endcap
Xwire41 _591_/Q uio_out[3] VPWR VPWR VGND VGND gf180mcu_fd_sc_mcu7t5v0__buf_3
Xwire52 wire52/I wire52/Z VPWR VPWR VGND VGND gf180mcu_fd_sc_mcu7t5v0__clkbuf_2
XTAP_TAPCELL_ROW_6_141 VPWR VGND gf180mcu_fd_sc_mcu7t5v0__filltie
XFILLER_30_457 VPWR VPWR VGND VGND gf180mcu_fd_sc_mcu7t5v0__fillcap_4
XFILLER_38_568 VPWR VPWR VGND VGND gf180mcu_fd_sc_mcu7t5v0__fillcap_4
XFILLER_38_546 VPWR VPWR VGND VGND gf180mcu_fd_sc_mcu7t5v0__fill_2
XFILLER_19_2 VPWR VPWR VGND VGND gf180mcu_fd_sc_mcu7t5v0__fillcap_64
XFILLER_17_66 VPWR VPWR VGND VGND gf180mcu_fd_sc_mcu7t5v0__fillcap_4
XFILLER_12_424 VPWR VPWR VGND VGND gf180mcu_fd_sc_mcu7t5v0__fill_1
XFILLER_12_457 VPWR VPWR VGND VGND gf180mcu_fd_sc_mcu7t5v0__fillcap_64
XFILLER_24_295 VPWR VPWR VGND VGND gf180mcu_fd_sc_mcu7t5v0__fill_1
XTAP_TAPCELL_ROW_17_235 VPWR VGND gf180mcu_fd_sc_mcu7t5v0__filltie
XFILLER_38_310 VPWR VPWR VGND VGND gf180mcu_fd_sc_mcu7t5v0__fill_1
XFILLER_26_527 VPWR VPWR VGND VGND gf180mcu_fd_sc_mcu7t5v0__fillcap_8
XPHY_EDGE_ROW_3_Right_3 VPWR VGND gf180mcu_fd_sc_mcu7t5v0__endcap
XFILLER_1_604 VPWR VPWR VGND VGND gf180mcu_fd_sc_mcu7t5v0__fill_1
X_492_ _492_/A1 _492_/A2 _536_/B _588_/D VPWR VPWR VGND VGND gf180mcu_fd_sc_mcu7t5v0__aoi21_1
XTAP_TAPCELL_ROW_14_205 VPWR VGND gf180mcu_fd_sc_mcu7t5v0__filltie
X_561_ _564_/A2 _561_/A2 _568_/B _621_/D VPWR VPWR VGND VGND gf180mcu_fd_sc_mcu7t5v0__oai21_1
XFILLER_8_247 VPWR VPWR VGND VGND gf180mcu_fd_sc_mcu7t5v0__fillcap_64
XFILLER_35_302 VPWR VPWR VGND VGND gf180mcu_fd_sc_mcu7t5v0__fill_2
XFILLER_23_508 VPWR VPWR VGND VGND gf180mcu_fd_sc_mcu7t5v0__fillcap_4
XTAP_TAPCELL_ROW_36_396 VPWR VGND gf180mcu_fd_sc_mcu7t5v0__filltie
XFILLER_26_324 VPWR VPWR VGND VGND gf180mcu_fd_sc_mcu7t5v0__fillcap_4
XFILLER_5_206 VPWR VPWR VGND VGND gf180mcu_fd_sc_mcu7t5v0__fillcap_4
XFILLER_14_34 VPWR VPWR VGND VGND gf180mcu_fd_sc_mcu7t5v0__fill_1
X_613_ _613_/D _628_/CLK _613_/Q VPWR VPWR VGND VGND gf180mcu_fd_sc_mcu7t5v0__dffq_1
X_475_ _479_/A3 _481_/A3 _475_/B _476_/A2 VPWR VPWR VGND VGND gf180mcu_fd_sc_mcu7t5v0__aoi21_1
X_544_ _615_/Q _541_/Z _578_/B _545_/A2 VPWR VPWR VGND VGND gf180mcu_fd_sc_mcu7t5v0__oai21_1
XFILLER_9_556 VPWR VPWR VGND VGND gf180mcu_fd_sc_mcu7t5v0__fillcap_4
XFILLER_23_305 VPWR VPWR VGND VGND gf180mcu_fd_sc_mcu7t5v0__fillcap_4
Xrebuffer62 _364_/A2 _400_/A3 VPWR VPWR VGND VGND gf180mcu_fd_sc_mcu7t5v0__buf_8
XFILLER_22_371 VPWR VPWR VGND VGND gf180mcu_fd_sc_mcu7t5v0__fillcap_4
XFILLER_25_66 VPWR VPWR VGND VGND gf180mcu_fd_sc_mcu7t5v0__fillcap_4
XFILLER_22_393 VPWR VPWR VGND VGND gf180mcu_fd_sc_mcu7t5v0__fillcap_8
XFILLER_2_37 VPWR VPWR VGND VGND gf180mcu_fd_sc_mcu7t5v0__fillcap_64
X_527_ _599_/Q _535_/A2 _528_/A2 VPWR VPWR VGND VGND gf180mcu_fd_sc_mcu7t5v0__nand2_1
X_458_ _610_/D _458_/A2 _458_/B _459_/S VPWR VPWR VGND VGND gf180mcu_fd_sc_mcu7t5v0__aoi21_1
X_389_ _437_/B _437_/A2 _481_/A2 VPWR VPWR VGND VGND gf180mcu_fd_sc_mcu7t5v0__nor2_2
XTAP_TAPCELL_ROW_30_347 VPWR VGND gf180mcu_fd_sc_mcu7t5v0__filltie
XTAP_TAPCELL_ROW_38_425 VPWR VGND gf180mcu_fd_sc_mcu7t5v0__filltie
XTAP_TAPCELL_ROW_38_414 VPWR VGND gf180mcu_fd_sc_mcu7t5v0__filltie
XFILLER_27_496 VPWR VPWR VGND VGND gf180mcu_fd_sc_mcu7t5v0__fill_2
X_312_ _399_/C _310_/I _312_/Z VPWR VPWR VGND VGND gf180mcu_fd_sc_mcu7t5v0__or2_1
XFILLER_36_271 VPWR VPWR VGND VGND gf180mcu_fd_sc_mcu7t5v0__fill_2
XFILLER_24_400 VPWR VPWR VGND VGND gf180mcu_fd_sc_mcu7t5v0__fill_1
XFILLER_22_34 VPWR VPWR VGND VGND gf180mcu_fd_sc_mcu7t5v0__fill_1
XTAP_TAPCELL_ROW_6_142 VPWR VGND gf180mcu_fd_sc_mcu7t5v0__filltie
XFILLER_15_400 VPWR VPWR VGND VGND gf180mcu_fd_sc_mcu7t5v0__fillcap_4
XFILLER_15_422 VPWR VPWR VGND VGND gf180mcu_fd_sc_mcu7t5v0__fill_1
XFILLER_15_477 VPWR VPWR VGND VGND gf180mcu_fd_sc_mcu7t5v0__fillcap_8
XFILLER_27_282 VPWR VPWR VGND VGND gf180mcu_fd_sc_mcu7t5v0__fillcap_16
XTAP_TAPCELL_ROW_12_188 VPWR VGND gf180mcu_fd_sc_mcu7t5v0__filltie
XFILLER_10_171 VPWR VPWR VGND VGND gf180mcu_fd_sc_mcu7t5v0__fillcap_4
XFILLER_2_381 VPWR VPWR VGND VGND gf180mcu_fd_sc_mcu7t5v0__fillcap_4
XFILLER_21_414 VPWR VPWR VGND VGND gf180mcu_fd_sc_mcu7t5v0__fillcap_4
XFILLER_21_458 VPWR VPWR VGND VGND gf180mcu_fd_sc_mcu7t5v0__fillcap_16
XTAP_TAPCELL_ROW_3_112 VPWR VGND gf180mcu_fd_sc_mcu7t5v0__filltie
XFILLER_24_241 VPWR VPWR VGND VGND gf180mcu_fd_sc_mcu7t5v0__fillcap_4
XFILLER_33_66 VPWR VPWR VGND VGND gf180mcu_fd_sc_mcu7t5v0__fillcap_4
XFILLER_35_517 VPWR VPWR VGND VGND gf180mcu_fd_sc_mcu7t5v0__fill_1
XTAP_TAPCELL_ROW_17_236 VPWR VGND gf180mcu_fd_sc_mcu7t5v0__filltie
XFILLER_31_2 VPWR VPWR VGND VGND gf180mcu_fd_sc_mcu7t5v0__fillcap_64
XFILLER_0_70 VPWR VPWR VGND VGND gf180mcu_fd_sc_mcu7t5v0__fillcap_32
XFILLER_34_594 VPWR VPWR VGND VGND gf180mcu_fd_sc_mcu7t5v0__fill_1
XFILLER_21_244 VPWR VPWR VGND VGND gf180mcu_fd_sc_mcu7t5v0__fillcap_16
XFILLER_0_104 VPWR VPWR VGND VGND gf180mcu_fd_sc_mcu7t5v0__fillcap_32
X_560_ _621_/Q _560_/A2 _561_/A2 VPWR VPWR VGND VGND gf180mcu_fd_sc_mcu7t5v0__nor2_1
XFILLER_29_377 VPWR VPWR VGND VGND gf180mcu_fd_sc_mcu7t5v0__fill_1
X_491_ input2/Z _519_/B1 _517_/B1 _596_/Q _492_/A2 VPWR VPWR VGND VGND gf180mcu_fd_sc_mcu7t5v0__aoi22_1
XTAP_TAPCELL_ROW_14_206 VPWR VGND gf180mcu_fd_sc_mcu7t5v0__filltie
XPHY_EDGE_ROW_13_Right_13 VPWR VGND gf180mcu_fd_sc_mcu7t5v0__endcap
XPHY_EDGE_ROW_22_Right_22 VPWR VGND gf180mcu_fd_sc_mcu7t5v0__endcap
XFILLER_38_130 VPWR VPWR VGND VGND gf180mcu_fd_sc_mcu7t5v0__fill_1
XFILLER_26_303 VPWR VPWR VGND VGND gf180mcu_fd_sc_mcu7t5v0__fillcap_4
XPHY_EDGE_ROW_31_Right_31 VPWR VGND gf180mcu_fd_sc_mcu7t5v0__endcap
XTAP_TAPCELL_ROW_36_397 VPWR VGND gf180mcu_fd_sc_mcu7t5v0__filltie
XFILLER_22_520 VPWR VPWR VGND VGND gf180mcu_fd_sc_mcu7t5v0__fillcap_4
XFILLER_22_597 VPWR VPWR VGND VGND gf180mcu_fd_sc_mcu7t5v0__fillcap_8
XFILLER_30_34 VPWR VPWR VGND VGND gf180mcu_fd_sc_mcu7t5v0__fill_1
XFILLER_17_347 VPWR VPWR VGND VGND gf180mcu_fd_sc_mcu7t5v0__fill_2
XTAP_TAPCELL_ROW_27_320 VPWR VGND gf180mcu_fd_sc_mcu7t5v0__filltie
X_612_ _612_/D _616_/CLK _612_/Q VPWR VPWR VGND VGND gf180mcu_fd_sc_mcu7t5v0__dffq_1
X_543_ _615_/Q _541_/Z _543_/Z VPWR VPWR VGND VGND gf180mcu_fd_sc_mcu7t5v0__and2_1
X_474_ _474_/A1 _474_/A2 _610_/D _474_/C _476_/A1 VPWR VPWR VGND VGND gf180mcu_fd_sc_mcu7t5v0__oai211_1
XFILLER_23_317 VPWR VPWR VGND VGND gf180mcu_fd_sc_mcu7t5v0__fillcap_8
XTAP_TAPCELL_ROW_33_367 VPWR VGND gf180mcu_fd_sc_mcu7t5v0__filltie
Xrebuffer63 _325_/A2 _364_/A2 VPWR VPWR VGND VGND gf180mcu_fd_sc_mcu7t5v0__buf_8
XFILLER_22_350 VPWR VPWR VGND VGND gf180mcu_fd_sc_mcu7t5v0__fill_1
XFILLER_26_177 VPWR VPWR VGND VGND gf180mcu_fd_sc_mcu7t5v0__fillcap_64
XFILLER_9_2 VPWR VPWR VGND VGND gf180mcu_fd_sc_mcu7t5v0__fillcap_64
XFILLER_6_527 VPWR VPWR VGND VGND gf180mcu_fd_sc_mcu7t5v0__fillcap_64
XFILLER_1_276 VPWR VPWR VGND VGND gf180mcu_fd_sc_mcu7t5v0__fillcap_4
XFILLER_33_604 VPWR VPWR VGND VGND gf180mcu_fd_sc_mcu7t5v0__fill_1
X_526_ _526_/A1 _526_/A2 _532_/B _598_/D VPWR VPWR VGND VGND gf180mcu_fd_sc_mcu7t5v0__aoi21_1
X_457_ _457_/A1 _457_/A2 _458_/B VPWR VPWR VGND VGND gf180mcu_fd_sc_mcu7t5v0__nand2_1
X_388_ _611_/D _388_/A2 _388_/Z VPWR VPWR VGND VGND gf180mcu_fd_sc_mcu7t5v0__and2_1
XTAP_TAPCELL_ROW_30_348 VPWR VGND gf180mcu_fd_sc_mcu7t5v0__filltie
XTAP_TAPCELL_ROW_38_415 VPWR VGND gf180mcu_fd_sc_mcu7t5v0__filltie
XFILLER_23_136 VPWR VPWR VGND VGND gf180mcu_fd_sc_mcu7t5v0__fillcap_4
XFILLER_15_604 VPWR VPWR VGND VGND gf180mcu_fd_sc_mcu7t5v0__fill_1
X_311_ _399_/C _310_/I _332_/B VPWR VPWR VGND VGND gf180mcu_fd_sc_mcu7t5v0__nor2_1
XFILLER_37_206 VPWR VPWR VGND VGND gf180mcu_fd_sc_mcu7t5v0__fillcap_4
XFILLER_33_489 VPWR VPWR VGND VGND gf180mcu_fd_sc_mcu7t5v0__fill_1
X_509_ _609_/Q _519_/A2 _517_/B1 _601_/Q _512_/A1 VPWR VPWR VGND VGND gf180mcu_fd_sc_mcu7t5v0__aoi22_1
Xwire43 _590_/Q uio_out[2] VPWR VPWR VGND VGND gf180mcu_fd_sc_mcu7t5v0__buf_3
XTAP_TAPCELL_ROW_6_143 VPWR VGND gf180mcu_fd_sc_mcu7t5v0__filltie
XFILLER_19_206 VPWR VPWR VGND VGND gf180mcu_fd_sc_mcu7t5v0__fillcap_4
XFILLER_15_489 VPWR VPWR VGND VGND gf180mcu_fd_sc_mcu7t5v0__fill_1
XTAP_TAPCELL_ROW_12_189 VPWR VGND gf180mcu_fd_sc_mcu7t5v0__filltie
XFILLER_8_37 VPWR VPWR VGND VGND gf180mcu_fd_sc_mcu7t5v0__fillcap_64
XFILLER_0_308 VPWR VPWR VGND VGND gf180mcu_fd_sc_mcu7t5v0__fillcap_32
XTAP_TAPCELL_ROW_3_113 VPWR VGND gf180mcu_fd_sc_mcu7t5v0__filltie
XFILLER_29_559 VPWR VPWR VGND VGND gf180mcu_fd_sc_mcu7t5v0__fill_1
XPHY_EDGE_ROW_9_Left_48 VPWR VGND gf180mcu_fd_sc_mcu7t5v0__endcap
XFILLER_35_507 VPWR VPWR VGND VGND gf180mcu_fd_sc_mcu7t5v0__fillcap_8
XTAP_TAPCELL_ROW_17_237 VPWR VGND gf180mcu_fd_sc_mcu7t5v0__filltie
XFILLER_11_492 VPWR VPWR VGND VGND gf180mcu_fd_sc_mcu7t5v0__fillcap_64
XFILLER_24_2 VPWR VPWR VGND VGND gf180mcu_fd_sc_mcu7t5v0__fillcap_32
XFILLER_21_212 VPWR VPWR VGND VGND gf180mcu_fd_sc_mcu7t5v0__fillcap_32
XFILLER_0_138 VPWR VPWR VGND VGND gf180mcu_fd_sc_mcu7t5v0__fillcap_32
XFILLER_28_34 VPWR VPWR VGND VGND gf180mcu_fd_sc_mcu7t5v0__fill_1
XFILLER_29_367 VPWR VPWR VGND VGND gf180mcu_fd_sc_mcu7t5v0__fillcap_4
X_490_ _604_/Q _519_/A2 _517_/A2 _580_/Q _492_/A1 VPWR VPWR VGND VGND gf180mcu_fd_sc_mcu7t5v0__aoi22_1
XTAP_TAPCELL_ROW_14_207 VPWR VGND gf180mcu_fd_sc_mcu7t5v0__filltie
XFILLER_25_573 VPWR VPWR VGND VGND gf180mcu_fd_sc_mcu7t5v0__fill_2
XTAP_TAPCELL_ROW_22_273 VPWR VGND gf180mcu_fd_sc_mcu7t5v0__filltie
XFILLER_31_532 VPWR VPWR VGND VGND gf180mcu_fd_sc_mcu7t5v0__fill_2
XFILLER_7_282 VPWR VPWR VGND VGND gf180mcu_fd_sc_mcu7t5v0__fillcap_64
XFILLER_38_164 VPWR VPWR VGND VGND gf180mcu_fd_sc_mcu7t5v0__fillcap_4
XFILLER_38_142 VPWR VPWR VGND VGND gf180mcu_fd_sc_mcu7t5v0__fill_2
XFILLER_26_337 VPWR VPWR VGND VGND gf180mcu_fd_sc_mcu7t5v0__fillcap_4
XTAP_TAPCELL_ROW_36_398 VPWR VGND gf180mcu_fd_sc_mcu7t5v0__filltie
XFILLER_22_510 VPWR VPWR VGND VGND gf180mcu_fd_sc_mcu7t5v0__fill_2
X_473_ _444_/B _443_/B _481_/A3 VPWR VPWR VGND VGND gf180mcu_fd_sc_mcu7t5v0__nand2_1
XTAP_TAPCELL_ROW_27_321 VPWR VGND gf180mcu_fd_sc_mcu7t5v0__filltie
XFILLER_29_142 VPWR VPWR VGND VGND gf180mcu_fd_sc_mcu7t5v0__fillcap_64
X_542_ wire52/Z _542_/A2 _541_/Z _614_/D VPWR VPWR VGND VGND gf180mcu_fd_sc_mcu7t5v0__nor3_1
X_611_ _611_/D _611_/CLK _611_/Q VPWR VPWR VGND VGND gf180mcu_fd_sc_mcu7t5v0__dffq_1
XFILLER_4_241 VPWR VPWR VGND VGND gf180mcu_fd_sc_mcu7t5v0__fillcap_4
XTAP_TAPCELL_ROW_33_368 VPWR VGND gf180mcu_fd_sc_mcu7t5v0__filltie
XFILLER_8_591 VPWR VPWR VGND VGND gf180mcu_fd_sc_mcu7t5v0__fillcap_4
Xrebuffer64 _325_/A2 _447_/A2 VPWR VPWR VGND VGND gf180mcu_fd_sc_mcu7t5v0__buf_8
XFILLER_14_329 VPWR VPWR VGND VGND gf180mcu_fd_sc_mcu7t5v0__fill_2
XFILLER_26_101 VPWR VPWR VGND VGND gf180mcu_fd_sc_mcu7t5v0__fillcap_4
XPHY_EDGE_ROW_38_Left_77 VPWR VGND gf180mcu_fd_sc_mcu7t5v0__endcap
X_525_ _598_/Q _535_/A2 _526_/A2 VPWR VPWR VGND VGND gf180mcu_fd_sc_mcu7t5v0__nand2_1
X_456_ _475_/B _474_/A2 _456_/A3 _456_/A4 _457_/A2 VPWR VPWR VGND VGND gf180mcu_fd_sc_mcu7t5v0__nand4_1
X_387_ _387_/A1 _437_/A2 _387_/Z VPWR VPWR VGND VGND gf180mcu_fd_sc_mcu7t5v0__or2_1
XTAP_TAPCELL_ROW_30_349 VPWR VGND gf180mcu_fd_sc_mcu7t5v0__filltie
XFILLER_5_594 VPWR VPWR VGND VGND gf180mcu_fd_sc_mcu7t5v0__fillcap_8
XTAP_TAPCELL_ROW_38_416 VPWR VGND gf180mcu_fd_sc_mcu7t5v0__filltie
XFILLER_36_476 VPWR VPWR VGND VGND gf180mcu_fd_sc_mcu7t5v0__fillcap_4
XFILLER_36_34 VPWR VPWR VGND VGND gf180mcu_fd_sc_mcu7t5v0__fill_1
X_310_ _310_/I _604_/D VPWR VPWR VGND VGND gf180mcu_fd_sc_mcu7t5v0__clkinv_1
XFILLER_27_498 VPWR VPWR VGND VGND gf180mcu_fd_sc_mcu7t5v0__fill_1
XFILLER_10_387 VPWR VPWR VGND VGND gf180mcu_fd_sc_mcu7t5v0__fillcap_32
XTAP_TAPCELL_ROW_9_163 VPWR VGND gf180mcu_fd_sc_mcu7t5v0__filltie
XFILLER_2_597 VPWR VPWR VGND VGND gf180mcu_fd_sc_mcu7t5v0__fillcap_8
X_508_ _508_/A1 _508_/A2 _536_/B _592_/D VPWR VPWR VGND VGND gf180mcu_fd_sc_mcu7t5v0__aoi21_1
XFILLER_33_457 VPWR VPWR VGND VGND gf180mcu_fd_sc_mcu7t5v0__fill_1
XFILLER_33_435 VPWR VPWR VGND VGND gf180mcu_fd_sc_mcu7t5v0__fill_2
XFILLER_20_107 VPWR VPWR VGND VGND gf180mcu_fd_sc_mcu7t5v0__fillcap_64
X_439_ _437_/B _438_/I _439_/S _582_/D VPWR VPWR VGND VGND gf180mcu_fd_sc_mcu7t5v0__mux2_2
XFILLER_36_273 VPWR VPWR VGND VGND gf180mcu_fd_sc_mcu7t5v0__fill_1
Xwire33 _595_/Q uio_out[7] VPWR VPWR VGND VGND gf180mcu_fd_sc_mcu7t5v0__buf_4
XTAP_TAPCELL_ROW_6_144 VPWR VGND gf180mcu_fd_sc_mcu7t5v0__filltie
XFILLER_30_416 VPWR VPWR VGND VGND gf180mcu_fd_sc_mcu7t5v0__fillcap_4
XFILLER_6_177 VPWR VPWR VGND VGND gf180mcu_fd_sc_mcu7t5v0__fillcap_64
XFILLER_38_516 VPWR VPWR VGND VGND gf180mcu_fd_sc_mcu7t5v0__fill_2
XPHY_EDGE_ROW_25_Left_64 VPWR VGND gf180mcu_fd_sc_mcu7t5v0__endcap
XFILLER_33_276 VPWR VPWR VGND VGND gf180mcu_fd_sc_mcu7t5v0__fillcap_4
XTAP_TAPCELL_ROW_3_114 VPWR VGND gf180mcu_fd_sc_mcu7t5v0__filltie
XFILLER_3_136 VPWR VPWR VGND VGND gf180mcu_fd_sc_mcu7t5v0__fillcap_4
XTAP_TAPCELL_ROW_17_238 VPWR VGND gf180mcu_fd_sc_mcu7t5v0__filltie
XFILLER_28_593 VPWR VPWR VGND VGND gf180mcu_fd_sc_mcu7t5v0__fill_2
XFILLER_15_276 VPWR VPWR VGND VGND gf180mcu_fd_sc_mcu7t5v0__fillcap_4
XFILLER_7_486 VPWR VPWR VGND VGND gf180mcu_fd_sc_mcu7t5v0__fillcap_4
XFILLER_17_2 VPWR VPWR VGND VGND gf180mcu_fd_sc_mcu7t5v0__fillcap_64
XFILLER_21_268 VPWR VPWR VGND VGND gf180mcu_fd_sc_mcu7t5v0__fillcap_4
XFILLER_12_279 VPWR VPWR VGND VGND gf180mcu_fd_sc_mcu7t5v0__fillcap_16
XTAP_TAPCELL_ROW_14_208 VPWR VGND gf180mcu_fd_sc_mcu7t5v0__filltie
XTAP_TAPCELL_ROW_22_274 VPWR VGND gf180mcu_fd_sc_mcu7t5v0__filltie
XFILLER_35_349 VPWR VPWR VGND VGND gf180mcu_fd_sc_mcu7t5v0__fill_1
XFILLER_11_290 VPWR VPWR VGND VGND gf180mcu_fd_sc_mcu7t5v0__fill_2
XPHY_EDGE_ROW_7_Right_7 VPWR VGND gf180mcu_fd_sc_mcu7t5v0__endcap
XTAP_TAPCELL_ROW_36_399 VPWR VGND gf180mcu_fd_sc_mcu7t5v0__filltie
XFILLER_34_382 VPWR VPWR VGND VGND gf180mcu_fd_sc_mcu7t5v0__fill_2
XFILLER_14_37 VPWR VPWR VGND VGND gf180mcu_fd_sc_mcu7t5v0__fillcap_64
XFILLER_22_566 VPWR VPWR VGND VGND gf180mcu_fd_sc_mcu7t5v0__fillcap_16
XPHY_EDGE_ROW_12_Left_51 VPWR VGND gf180mcu_fd_sc_mcu7t5v0__endcap
X_610_ _610_/D _611_/CLK _610_/Q VPWR VPWR VGND VGND gf180mcu_fd_sc_mcu7t5v0__dffq_1
XFILLER_17_327 VPWR VPWR VGND VGND gf180mcu_fd_sc_mcu7t5v0__fillcap_4
XFILLER_17_349 VPWR VPWR VGND VGND gf180mcu_fd_sc_mcu7t5v0__fill_1
X_472_ _472_/A1 _472_/A2 _472_/A3 _476_/B VPWR VPWR VGND VGND gf180mcu_fd_sc_mcu7t5v0__nor3_1
XTAP_TAPCELL_ROW_27_322 VPWR VGND gf180mcu_fd_sc_mcu7t5v0__filltie
X_541_ _613_/Q _612_/Q _614_/Q _541_/Z VPWR VPWR VGND VGND gf180mcu_fd_sc_mcu7t5v0__and3_1
XTAP_TAPCELL_ROW_33_369 VPWR VGND gf180mcu_fd_sc_mcu7t5v0__filltie
XFILLER_16_382 VPWR VPWR VGND VGND gf180mcu_fd_sc_mcu7t5v0__fill_2
XFILLER_31_396 VPWR VPWR VGND VGND gf180mcu_fd_sc_mcu7t5v0__fillcap_16
XFILLER_27_603 VPWR VPWR VGND VGND gf180mcu_fd_sc_mcu7t5v0__fill_2
XFILLER_1_212 VPWR VPWR VGND VGND gf180mcu_fd_sc_mcu7t5v0__fillcap_64
X_524_ _524_/A1 _524_/A2 _536_/B _597_/D VPWR VPWR VGND VGND gf180mcu_fd_sc_mcu7t5v0__aoi21_1
XFILLER_13_352 VPWR VPWR VGND VGND gf180mcu_fd_sc_mcu7t5v0__fillcap_4
X_455_ _460_/A2 _455_/A2 _455_/B _463_/B _456_/A4 VPWR VPWR VGND VGND gf180mcu_fd_sc_mcu7t5v0__oai211_1
X_386_ _420_/C _409_/B _437_/A2 VPWR VPWR VGND VGND gf180mcu_fd_sc_mcu7t5v0__nor2_2
XFILLER_5_562 VPWR VPWR VGND VGND gf180mcu_fd_sc_mcu7t5v0__fillcap_32
XTAP_TAPCELL_ROW_38_417 VPWR VGND gf180mcu_fd_sc_mcu7t5v0__filltie
XFILLER_36_400 VPWR VPWR VGND VGND gf180mcu_fd_sc_mcu7t5v0__fill_2
XFILLER_27_455 VPWR VPWR VGND VGND gf180mcu_fd_sc_mcu7t5v0__fill_1
XFILLER_27_488 VPWR VPWR VGND VGND gf180mcu_fd_sc_mcu7t5v0__fill_2
XFILLER_10_311 VPWR VPWR VGND VGND gf180mcu_fd_sc_mcu7t5v0__fillcap_4
XFILLER_22_171 VPWR VPWR VGND VGND gf180mcu_fd_sc_mcu7t5v0__fillcap_4
XTAP_TAPCELL_ROW_9_164 VPWR VGND gf180mcu_fd_sc_mcu7t5v0__filltie
XFILLER_2_521 VPWR VPWR VGND VGND gf180mcu_fd_sc_mcu7t5v0__fillcap_4
X_507_ input6/Z _510_/A2 _517_/B1 _600_/Q _508_/A2 VPWR VPWR VGND VGND gf180mcu_fd_sc_mcu7t5v0__aoi22_1
XFILLER_33_447 VPWR VPWR VGND VGND gf180mcu_fd_sc_mcu7t5v0__fill_1
XFILLER_9_142 VPWR VPWR VGND VGND gf180mcu_fd_sc_mcu7t5v0__fillcap_64
X_369_ _360_/C _378_/A1 _369_/B _379_/C _374_/A2 VPWR VPWR VGND VGND gf180mcu_fd_sc_mcu7t5v0__oai211_2
X_438_ _438_/I _587_/D VPWR VPWR VGND VGND gf180mcu_fd_sc_mcu7t5v0__clkinv_1
XFILLER_3_72 VPWR VPWR VGND VGND gf180mcu_fd_sc_mcu7t5v0__fillcap_64
Xwire45 _589_/Q uio_out[1] VPWR VPWR VGND VGND gf180mcu_fd_sc_mcu7t5v0__buf_3
XFILLER_36_241 VPWR VPWR VGND VGND gf180mcu_fd_sc_mcu7t5v0__fillcap_4
XFILLER_22_37 VPWR VPWR VGND VGND gf180mcu_fd_sc_mcu7t5v0__fillcap_64
XTAP_TAPCELL_ROW_6_145 VPWR VGND gf180mcu_fd_sc_mcu7t5v0__filltie
XFILLER_7_602 VPWR VPWR VGND VGND gf180mcu_fd_sc_mcu7t5v0__fill_2
XFILLER_6_101 VPWR VPWR VGND VGND gf180mcu_fd_sc_mcu7t5v0__fillcap_4
XFILLER_23_480 VPWR VPWR VGND VGND gf180mcu_fd_sc_mcu7t5v0__fill_2
XFILLER_18_241 VPWR VPWR VGND VGND gf180mcu_fd_sc_mcu7t5v0__fillcap_4
XTAP_TAPCELL_ROW_11_180 VPWR VGND gf180mcu_fd_sc_mcu7t5v0__filltie
XFILLER_37_594 VPWR VPWR VGND VGND gf180mcu_fd_sc_mcu7t5v0__fillcap_8
XTAP_TAPCELL_ROW_3_115 VPWR VGND gf180mcu_fd_sc_mcu7t5v0__filltie
XFILLER_30_247 VPWR VPWR VGND VGND gf180mcu_fd_sc_mcu7t5v0__fillcap_64
XFILLER_34_597 VPWR VPWR VGND VGND gf180mcu_fd_sc_mcu7t5v0__fillcap_8
XFILLER_34_586 VPWR VPWR VGND VGND gf180mcu_fd_sc_mcu7t5v0__fillcap_8
XFILLER_19_594 VPWR VPWR VGND VGND gf180mcu_fd_sc_mcu7t5v0__fillcap_8
XFILLER_29_314 VPWR VPWR VGND VGND gf180mcu_fd_sc_mcu7t5v0__fillcap_4
XTAP_TAPCELL_ROW_14_209 VPWR VGND gf180mcu_fd_sc_mcu7t5v0__filltie
XFILLER_25_575 VPWR VPWR VGND VGND gf180mcu_fd_sc_mcu7t5v0__fill_1
XFILLER_29_347 VPWR VPWR VGND VGND gf180mcu_fd_sc_mcu7t5v0__fill_2
XFILLER_12_247 VPWR VPWR VGND VGND gf180mcu_fd_sc_mcu7t5v0__fillcap_32
XTAP_TAPCELL_ROW_22_275 VPWR VGND gf180mcu_fd_sc_mcu7t5v0__filltie
XFILLER_4_457 VPWR VPWR VGND VGND gf180mcu_fd_sc_mcu7t5v0__fillcap_64
XFILLER_16_597 VPWR VPWR VGND VGND gf180mcu_fd_sc_mcu7t5v0__fillcap_8
XFILLER_38_100 VPWR VPWR VGND VGND gf180mcu_fd_sc_mcu7t5v0__fill_2
XFILLER_38_122 VPWR VPWR VGND VGND gf180mcu_fd_sc_mcu7t5v0__fillcap_8
Xclkbuf_3_5__f_clk clkbuf_0_clk/Z _624_/CLK VPWR VPWR VGND VGND gf180mcu_fd_sc_mcu7t5v0__clkbuf_8
XFILLER_26_328 VPWR VPWR VGND VGND gf180mcu_fd_sc_mcu7t5v0__fill_1
XFILLER_1_416 VPWR VPWR VGND VGND gf180mcu_fd_sc_mcu7t5v0__fillcap_4
XFILLER_30_37 VPWR VPWR VGND VGND gf180mcu_fd_sc_mcu7t5v0__fillcap_64
X_540_ _613_/Q _612_/Q _614_/Q _542_/A2 VPWR VPWR VGND VGND gf180mcu_fd_sc_mcu7t5v0__aoi21_1
XFILLER_13_556 VPWR VPWR VGND VGND gf180mcu_fd_sc_mcu7t5v0__fillcap_4
XFILLER_25_372 VPWR VPWR VGND VGND gf180mcu_fd_sc_mcu7t5v0__fillcap_4
XTAP_TAPCELL_ROW_27_323 VPWR VGND gf180mcu_fd_sc_mcu7t5v0__filltie
X_471_ _437_/B _481_/A2 _471_/S _584_/D VPWR VPWR VGND VGND gf180mcu_fd_sc_mcu7t5v0__mux2_2
XFILLER_35_136 VPWR VPWR VGND VGND gf180mcu_fd_sc_mcu7t5v0__fillcap_4
XFILLER_23_309 VPWR VPWR VGND VGND gf180mcu_fd_sc_mcu7t5v0__fill_2
X_523_ _597_/Q _535_/A2 _524_/A2 VPWR VPWR VGND VGND gf180mcu_fd_sc_mcu7t5v0__nand2_1
XFILLER_17_136 VPWR VPWR VGND VGND gf180mcu_fd_sc_mcu7t5v0__fillcap_4
XFILLER_9_346 VPWR VPWR VGND VGND gf180mcu_fd_sc_mcu7t5v0__fillcap_4
X_454_ _460_/A2 _443_/B _454_/B _454_/C _457_/A1 VPWR VPWR VGND VGND gf180mcu_fd_sc_mcu7t5v0__oai211_1
X_385_ _388_/A2 _387_/A1 _390_/A2 VPWR VPWR VGND VGND gf180mcu_fd_sc_mcu7t5v0__nand2_1
XTAP_TAPCELL_ROW_38_418 VPWR VGND gf180mcu_fd_sc_mcu7t5v0__filltie
XTAP_TAPCELL_ROW_9_165 VPWR VGND gf180mcu_fd_sc_mcu7t5v0__filltie
XFILLER_7_2 VPWR VPWR VGND VGND gf180mcu_fd_sc_mcu7t5v0__fillcap_64
XFILLER_18_401 VPWR VPWR VGND VGND gf180mcu_fd_sc_mcu7t5v0__fill_1
XFILLER_33_437 VPWR VPWR VGND VGND gf180mcu_fd_sc_mcu7t5v0__fill_1
X_506_ _608_/Q _519_/A2 _517_/A2 _584_/Q _508_/A1 VPWR VPWR VGND VGND gf180mcu_fd_sc_mcu7t5v0__aoi22_1
X_368_ _326_/B _368_/A2 _413_/B _368_/C _369_/B VPWR VPWR VGND VGND gf180mcu_fd_sc_mcu7t5v0__oai211_1
X_437_ _454_/C _437_/A2 _437_/B _438_/I VPWR VPWR VGND VGND gf180mcu_fd_sc_mcu7t5v0__aoi21_1
X_299_ _611_/Q _560_/A2 _300_/B VPWR VPWR VGND VGND gf180mcu_fd_sc_mcu7t5v0__or2_1
Xwire35 _594_/Q uio_out[6] VPWR VPWR VGND VGND gf180mcu_fd_sc_mcu7t5v0__buf_3
XFILLER_15_404 VPWR VPWR VGND VGND gf180mcu_fd_sc_mcu7t5v0__fill_2
XPHY_EDGE_ROW_29_Right_29 VPWR VGND gf180mcu_fd_sc_mcu7t5v0__endcap
XPHY_EDGE_ROW_38_Right_38 VPWR VGND gf180mcu_fd_sc_mcu7t5v0__endcap
XFILLER_23_492 VPWR VPWR VGND VGND gf180mcu_fd_sc_mcu7t5v0__fillcap_8
XFILLER_33_212 VPWR VPWR VGND VGND gf180mcu_fd_sc_mcu7t5v0__fillcap_64
XFILLER_21_418 VPWR VPWR VGND VGND gf180mcu_fd_sc_mcu7t5v0__fill_2
XTAP_TAPCELL_ROW_11_181 VPWR VGND gf180mcu_fd_sc_mcu7t5v0__filltie
XTAP_TAPCELL_ROW_3_116 VPWR VGND gf180mcu_fd_sc_mcu7t5v0__filltie
XFILLER_37_562 VPWR VPWR VGND VGND gf180mcu_fd_sc_mcu7t5v0__fillcap_32
XFILLER_15_212 VPWR VPWR VGND VGND gf180mcu_fd_sc_mcu7t5v0__fillcap_64
XFILLER_7_422 VPWR VPWR VGND VGND gf180mcu_fd_sc_mcu7t5v0__fillcap_64
XFILLER_2_171 VPWR VPWR VGND VGND gf180mcu_fd_sc_mcu7t5v0__fillcap_4
XFILLER_19_562 VPWR VPWR VGND VGND gf180mcu_fd_sc_mcu7t5v0__fillcap_32
XFILLER_34_554 VPWR VPWR VGND VGND gf180mcu_fd_sc_mcu7t5v0__fillcap_32
XFILLER_9_72 VPWR VPWR VGND VGND gf180mcu_fd_sc_mcu7t5v0__fillcap_64
XFILLER_28_37 VPWR VPWR VGND VGND gf180mcu_fd_sc_mcu7t5v0__fillcap_64
XTAP_TAPCELL_ROW_22_276 VPWR VGND gf180mcu_fd_sc_mcu7t5v0__filltie
XFILLER_31_524 VPWR VPWR VGND VGND gf180mcu_fd_sc_mcu7t5v0__fillcap_8
XFILLER_11_292 VPWR VPWR VGND VGND gf180mcu_fd_sc_mcu7t5v0__fill_1
XFILLER_22_2 VPWR VPWR VGND VGND gf180mcu_fd_sc_mcu7t5v0__fillcap_32
XFILLER_34_384 VPWR VPWR VGND VGND gf180mcu_fd_sc_mcu7t5v0__fill_1
XFILLER_22_524 VPWR VPWR VGND VGND gf180mcu_fd_sc_mcu7t5v0__fill_1
XFILLER_22_535 VPWR VPWR VGND VGND gf180mcu_fd_sc_mcu7t5v0__fill_2
XTAP_TAPCELL_ROW_35_390 VPWR VGND gf180mcu_fd_sc_mcu7t5v0__filltie
X_470_ _470_/A1 _464_/Z _470_/B1 _610_/D _471_/S VPWR VPWR VGND VGND gf180mcu_fd_sc_mcu7t5v0__aoi22_1
X_599_ _599_/D _628_/CLK _599_/Q VPWR VPWR VGND VGND gf180mcu_fd_sc_mcu7t5v0__dffq_1
XFILLER_16_384 VPWR VPWR VGND VGND gf180mcu_fd_sc_mcu7t5v0__fill_1
XFILLER_10_527 VPWR VPWR VGND VGND gf180mcu_fd_sc_mcu7t5v0__fillcap_64
XTAP_TAPCELL_ROW_32_360 VPWR VGND gf180mcu_fd_sc_mcu7t5v0__filltie
X_522_ _522_/A1 _522_/A2 _532_/B _596_/D VPWR VPWR VGND VGND gf180mcu_fd_sc_mcu7t5v0__aoi21_1
X_453_ _468_/A2 _453_/A2 _453_/B1 _460_/B _454_/B VPWR VPWR VGND VGND gf180mcu_fd_sc_mcu7t5v0__oai22_2
XFILLER_32_107 VPWR VPWR VGND VGND gf180mcu_fd_sc_mcu7t5v0__fillcap_64
XFILLER_13_343 VPWR VPWR VGND VGND gf180mcu_fd_sc_mcu7t5v0__fillcap_4
X_384_ _384_/A1 _384_/A2 _454_/C _387_/A1 VPWR VPWR VGND VGND gf180mcu_fd_sc_mcu7t5v0__oai21_1
XTAP_TAPCELL_ROW_38_419 VPWR VGND gf180mcu_fd_sc_mcu7t5v0__filltie
XFILLER_36_457 VPWR VPWR VGND VGND gf180mcu_fd_sc_mcu7t5v0__fill_1
XFILLER_36_37 VPWR VPWR VGND VGND gf180mcu_fd_sc_mcu7t5v0__fillcap_64
XFILLER_14_107 VPWR VPWR VGND VGND gf180mcu_fd_sc_mcu7t5v0__fillcap_64
XFILLER_27_413 VPWR VPWR VGND VGND gf180mcu_fd_sc_mcu7t5v0__fillcap_4
XFILLER_6_317 VPWR VPWR VGND VGND gf180mcu_fd_sc_mcu7t5v0__fillcap_64
XTAP_TAPCELL_ROW_9_166 VPWR VGND gf180mcu_fd_sc_mcu7t5v0__filltie
X_505_ input6/Z _510_/A2 _530_/A1 VPWR VPWR VGND VGND gf180mcu_fd_sc_mcu7t5v0__nand2_1
X_436_ _436_/A1 _436_/A2 _436_/A3 _439_/S VPWR VPWR VGND VGND gf180mcu_fd_sc_mcu7t5v0__nand3_1
X_367_ _401_/A1 _321_/I _607_/D _378_/A1 VPWR VPWR VGND VGND gf180mcu_fd_sc_mcu7t5v0__oai21_1
X_298_ _292_/I _319_/A2 _560_/A2 VPWR VPWR VGND VGND gf180mcu_fd_sc_mcu7t5v0__nand2_1
Xwire47 _588_/Q uio_out[0] VPWR VPWR VGND VGND gf180mcu_fd_sc_mcu7t5v0__buf_3
XFILLER_27_276 VPWR VPWR VGND VGND gf180mcu_fd_sc_mcu7t5v0__fillcap_4
XFILLER_27_298 VPWR VPWR VGND VGND gf180mcu_fd_sc_mcu7t5v0__fillcap_8
XFILLER_7_604 VPWR VPWR VGND VGND gf180mcu_fd_sc_mcu7t5v0__fill_1
X_419_ _481_/A2 _437_/B _419_/S _581_/D VPWR VPWR VGND VGND gf180mcu_fd_sc_mcu7t5v0__mux2_2
XTAP_TAPCELL_ROW_11_182 VPWR VGND gf180mcu_fd_sc_mcu7t5v0__filltie
XTAP_TAPCELL_ROW_3_117 VPWR VGND gf180mcu_fd_sc_mcu7t5v0__filltie
XFILLER_20_485 VPWR VPWR VGND VGND gf180mcu_fd_sc_mcu7t5v0__fillcap_16
XFILLER_24_279 VPWR VPWR VGND VGND gf180mcu_fd_sc_mcu7t5v0__fillcap_16
XFILLER_28_574 VPWR VPWR VGND VGND gf180mcu_fd_sc_mcu7t5v0__fill_1
XPHY_EDGE_ROW_29_Left_68 VPWR VGND gf180mcu_fd_sc_mcu7t5v0__endcap
XFILLER_34_544 VPWR VPWR VGND VGND gf180mcu_fd_sc_mcu7t5v0__fill_2
XTAP_TAPCELL_ROW_16_230 VPWR VGND gf180mcu_fd_sc_mcu7t5v0__filltie
XFILLER_29_349 VPWR VPWR VGND VGND gf180mcu_fd_sc_mcu7t5v0__fill_1
XTAP_TAPCELL_ROW_22_277 VPWR VGND gf180mcu_fd_sc_mcu7t5v0__filltie
XFILLER_11_282 VPWR VPWR VGND VGND gf180mcu_fd_sc_mcu7t5v0__fillcap_8
XTAP_TAPCELL_ROW_13_200 VPWR VGND gf180mcu_fd_sc_mcu7t5v0__filltie
XFILLER_38_168 VPWR VPWR VGND VGND gf180mcu_fd_sc_mcu7t5v0__fill_2
XFILLER_38_135 VPWR VPWR VGND VGND gf180mcu_fd_sc_mcu7t5v0__fill_1
XFILLER_3_492 VPWR VPWR VGND VGND gf180mcu_fd_sc_mcu7t5v0__fillcap_64
XFILLER_15_2 VPWR VPWR VGND VGND gf180mcu_fd_sc_mcu7t5v0__fillcap_64
XFILLER_25_352 VPWR VPWR VGND VGND gf180mcu_fd_sc_mcu7t5v0__fill_2
XTAP_TAPCELL_ROW_35_391 VPWR VGND gf180mcu_fd_sc_mcu7t5v0__filltie
XFILLER_25_385 VPWR VPWR VGND VGND gf180mcu_fd_sc_mcu7t5v0__fillcap_4
X_598_ _598_/D _616_/CLK _598_/Q VPWR VPWR VGND VGND gf180mcu_fd_sc_mcu7t5v0__dffq_1
XFILLER_16_352 VPWR VPWR VGND VGND gf180mcu_fd_sc_mcu7t5v0__fillcap_4
XFILLER_16_374 VPWR VPWR VGND VGND gf180mcu_fd_sc_mcu7t5v0__fillcap_8
XFILLER_12_591 VPWR VPWR VGND VGND gf180mcu_fd_sc_mcu7t5v0__fillcap_4
XPHY_EDGE_ROW_16_Left_55 VPWR VGND gf180mcu_fd_sc_mcu7t5v0__endcap
XFILLER_34_171 VPWR VPWR VGND VGND gf180mcu_fd_sc_mcu7t5v0__fillcap_4
XTAP_TAPCELL_ROW_32_361 VPWR VGND gf180mcu_fd_sc_mcu7t5v0__filltie
X_521_ _596_/Q _535_/A2 _522_/A2 VPWR VPWR VGND VGND gf180mcu_fd_sc_mcu7t5v0__nand2_1
XFILLER_13_311 VPWR VPWR VGND VGND gf180mcu_fd_sc_mcu7t5v0__fillcap_4
X_452_ _310_/I _396_/B _452_/B _452_/C _453_/B1 VPWR VPWR VGND VGND gf180mcu_fd_sc_mcu7t5v0__aoi211_1
X_383_ _604_/D _321_/I _409_/B _383_/B2 _384_/A2 VPWR VPWR VGND VGND gf180mcu_fd_sc_mcu7t5v0__aoi22_1
XFILLER_15_72 VPWR VPWR VGND VGND gf180mcu_fd_sc_mcu7t5v0__fillcap_64
XTAP_TAPCELL_ROW_38_409 VPWR VGND gf180mcu_fd_sc_mcu7t5v0__filltie
XFILLER_16_171 VPWR VPWR VGND VGND gf180mcu_fd_sc_mcu7t5v0__fillcap_4
XFILLER_8_381 VPWR VPWR VGND VGND gf180mcu_fd_sc_mcu7t5v0__fillcap_4
XFILLER_35_480 VPWR VPWR VGND VGND gf180mcu_fd_sc_mcu7t5v0__fill_2
XTAP_TAPCELL_ROW_9_167 VPWR VGND gf180mcu_fd_sc_mcu7t5v0__filltie
X_504_ _504_/A1 _504_/A2 _536_/B _591_/D VPWR VPWR VGND VGND gf180mcu_fd_sc_mcu7t5v0__aoi21_1
XFILLER_33_417 VPWR VPWR VGND VGND gf180mcu_fd_sc_mcu7t5v0__fill_2
X_366_ _396_/B _467_/C _421_/A1 VPWR VPWR VGND VGND gf180mcu_fd_sc_mcu7t5v0__nand2_1
X_435_ _475_/B _435_/A2 _436_/A3 VPWR VPWR VGND VGND gf180mcu_fd_sc_mcu7t5v0__nand2_1
XFILLER_26_480 VPWR VPWR VGND VGND gf180mcu_fd_sc_mcu7t5v0__fillcap_16
X_297_ _329_/A1 _620_/Q _339_/A2 VPWR VPWR VGND VGND gf180mcu_fd_sc_mcu7t5v0__nor2_2
Xwire37 _593_/Q uio_out[5] VPWR VPWR VGND VGND gf180mcu_fd_sc_mcu7t5v0__buf_3
XFILLER_24_439 VPWR VPWR VGND VGND gf180mcu_fd_sc_mcu7t5v0__fillcap_16
XTAP_TAPCELL_ROW_6_137 VPWR VGND gf180mcu_fd_sc_mcu7t5v0__filltie
XFILLER_15_406 VPWR VPWR VGND VGND gf180mcu_fd_sc_mcu7t5v0__fill_1
XFILLER_10_177 VPWR VPWR VGND VGND gf180mcu_fd_sc_mcu7t5v0__fillcap_64
XFILLER_2_387 VPWR VPWR VGND VGND gf180mcu_fd_sc_mcu7t5v0__fillcap_64
X_349_ _564_/A2 _306_/Z _349_/B1 _349_/B2 _568_/B _370_/B VPWR VPWR VGND VGND gf180mcu_fd_sc_mcu7t5v0__oai221_2
X_418_ _454_/C _418_/A2 _418_/B _418_/C _419_/S VPWR VPWR VGND VGND gf180mcu_fd_sc_mcu7t5v0__aoi211_2
XTAP_TAPCELL_ROW_11_183 VPWR VGND gf180mcu_fd_sc_mcu7t5v0__filltie
XTAP_TAPCELL_ROW_3_118 VPWR VGND gf180mcu_fd_sc_mcu7t5v0__filltie
XTAP_TAPCELL_ROW_19_250 VPWR VGND gf180mcu_fd_sc_mcu7t5v0__filltie
XFILLER_24_247 VPWR VPWR VGND VGND gf180mcu_fd_sc_mcu7t5v0__fillcap_32
XFILLER_20_453 VPWR VPWR VGND VGND gf180mcu_fd_sc_mcu7t5v0__fill_2
XFILLER_28_597 VPWR VPWR VGND VGND gf180mcu_fd_sc_mcu7t5v0__fillcap_8
XPHY_EDGE_ROW_4_Left_43 VPWR VGND gf180mcu_fd_sc_mcu7t5v0__endcap
XFILLER_23_72 VPWR VPWR VGND VGND gf180mcu_fd_sc_mcu7t5v0__fillcap_64
XFILLER_34_512 VPWR VPWR VGND VGND gf180mcu_fd_sc_mcu7t5v0__fillcap_8
XFILLER_21_206 VPWR VPWR VGND VGND gf180mcu_fd_sc_mcu7t5v0__fillcap_4
XFILLER_20_294 VPWR VPWR VGND VGND gf180mcu_fd_sc_mcu7t5v0__fill_2
XTAP_TAPCELL_ROW_22_278 VPWR VGND gf180mcu_fd_sc_mcu7t5v0__filltie
XPHY_EDGE_ROW_30_Left_69 VPWR VGND gf180mcu_fd_sc_mcu7t5v0__endcap
XTAP_TAPCELL_ROW_13_201 VPWR VGND gf180mcu_fd_sc_mcu7t5v0__filltie
XFILLER_7_276 VPWR VPWR VGND VGND gf180mcu_fd_sc_mcu7t5v0__fillcap_4
XFILLER_19_372 VPWR VPWR VGND VGND gf180mcu_fd_sc_mcu7t5v0__fillcap_4
XFILLER_30_592 VPWR VPWR VGND VGND gf180mcu_fd_sc_mcu7t5v0__fill_2
XFILLER_29_136 VPWR VPWR VGND VGND gf180mcu_fd_sc_mcu7t5v0__fillcap_4
XFILLER_25_364 VPWR VPWR VGND VGND gf180mcu_fd_sc_mcu7t5v0__fillcap_8
X_597_ _597_/D _607_/CLK _597_/Q VPWR VPWR VGND VGND gf180mcu_fd_sc_mcu7t5v0__dffq_1
XFILLER_16_397 VPWR VPWR VGND VGND gf180mcu_fd_sc_mcu7t5v0__fillcap_4
XFILLER_31_389 VPWR VPWR VGND VGND gf180mcu_fd_sc_mcu7t5v0__fill_2
XTAP_TAPCELL_ROW_32_362 VPWR VGND gf180mcu_fd_sc_mcu7t5v0__filltie
X_520_ _520_/A1 _520_/A2 _536_/B _595_/D VPWR VPWR VGND VGND gf180mcu_fd_sc_mcu7t5v0__aoi21_1
XFILLER_13_356 VPWR VPWR VGND VGND gf180mcu_fd_sc_mcu7t5v0__fill_2
X_451_ _450_/B _442_/Z _451_/B1 _451_/B2 _458_/A2 VPWR VPWR VGND VGND gf180mcu_fd_sc_mcu7t5v0__oai22_1
X_382_ _379_/C _607_/D _382_/A3 _383_/B2 VPWR VPWR VGND VGND gf180mcu_fd_sc_mcu7t5v0__nand3_1
XPHY_EDGE_ROW_33_Left_72 VPWR VGND gf180mcu_fd_sc_mcu7t5v0__endcap
XFILLER_31_72 VPWR VPWR VGND VGND gf180mcu_fd_sc_mcu7t5v0__fillcap_64
XFILLER_31_142 VPWR VPWR VGND VGND gf180mcu_fd_sc_mcu7t5v0__fillcap_64
XFILLER_35_492 VPWR VPWR VGND VGND gf180mcu_fd_sc_mcu7t5v0__fill_2
XTAP_TAPCELL_ROW_9_168 VPWR VGND gf180mcu_fd_sc_mcu7t5v0__filltie
X_503_ input5/Z _503_/A2 _517_/A2 _583_/Q _504_/A2 VPWR VPWR VGND VGND gf180mcu_fd_sc_mcu7t5v0__aoi22_1
X_296_ _578_/B wire52/I VPWR VPWR VGND VGND gf180mcu_fd_sc_mcu7t5v0__inv_1
X_365_ _608_/D _365_/A2 _365_/B _374_/A1 VPWR VPWR VGND VGND gf180mcu_fd_sc_mcu7t5v0__aoi21_1
XFILLER_13_142 VPWR VPWR VGND VGND gf180mcu_fd_sc_mcu7t5v0__fillcap_64
X_434_ _455_/A2 _456_/A3 _434_/B _435_/A2 VPWR VPWR VGND VGND gf180mcu_fd_sc_mcu7t5v0__oai21_1
XFILLER_5_352 VPWR VPWR VGND VGND gf180mcu_fd_sc_mcu7t5v0__fillcap_64
XFILLER_17_492 VPWR VPWR VGND VGND gf180mcu_fd_sc_mcu7t5v0__fillcap_8
XTAP_TAPCELL_ROW_6_138 VPWR VGND gf180mcu_fd_sc_mcu7t5v0__filltie
XFILLER_27_212 VPWR VPWR VGND VGND gf180mcu_fd_sc_mcu7t5v0__fillcap_64
XFILLER_10_101 VPWR VPWR VGND VGND gf180mcu_fd_sc_mcu7t5v0__fillcap_4
XFILLER_11_602 VPWR VPWR VGND VGND gf180mcu_fd_sc_mcu7t5v0__fill_2
XFILLER_2_311 VPWR VPWR VGND VGND gf180mcu_fd_sc_mcu7t5v0__fillcap_4
XFILLER_5_2 VPWR VPWR VGND VGND gf180mcu_fd_sc_mcu7t5v0__fillcap_64
XPHY_EDGE_ROW_16_Right_16 VPWR VGND gf180mcu_fd_sc_mcu7t5v0__endcap
X_417_ _411_/Z _417_/A2 _417_/B1 _417_/B2 _418_/A2 VPWR VPWR VGND VGND gf180mcu_fd_sc_mcu7t5v0__oai22_1
X_348_ _308_/Z _400_/A3 _406_/B VPWR VPWR VGND VGND gf180mcu_fd_sc_mcu7t5v0__nand2_1
XPHY_EDGE_ROW_25_Right_25 VPWR VGND gf180mcu_fd_sc_mcu7t5v0__endcap
XFILLER_38_2 VPWR VPWR VGND VGND gf180mcu_fd_sc_mcu7t5v0__fillcap_32
XTAP_TAPCELL_ROW_11_184 VPWR VGND gf180mcu_fd_sc_mcu7t5v0__filltie
XPHY_EDGE_ROW_34_Right_34 VPWR VGND gf180mcu_fd_sc_mcu7t5v0__endcap
XTAP_TAPCELL_ROW_3_119 VPWR VGND gf180mcu_fd_sc_mcu7t5v0__filltie
XTAP_TAPCELL_ROW_19_251 VPWR VGND gf180mcu_fd_sc_mcu7t5v0__filltie
XFILLER_11_487 VPWR VPWR VGND VGND gf180mcu_fd_sc_mcu7t5v0__fill_2
XFILLER_38_329 VPWR VPWR VGND VGND gf180mcu_fd_sc_mcu7t5v0__fill_1
XFILLER_29_318 VPWR VPWR VGND VGND gf180mcu_fd_sc_mcu7t5v0__fill_2
XTAP_TAPCELL_ROW_22_279 VPWR VGND gf180mcu_fd_sc_mcu7t5v0__filltie
Xclkbuf_3_0__f_clk clkbuf_0_clk/Z _611_/CLK VPWR VPWR VGND VGND gf180mcu_fd_sc_mcu7t5v0__clkbuf_8
XTAP_TAPCELL_ROW_13_202 VPWR VGND gf180mcu_fd_sc_mcu7t5v0__filltie
XFILLER_16_524 VPWR VPWR VGND VGND gf180mcu_fd_sc_mcu7t5v0__fill_1
XFILLER_24_590 VPWR VPWR VGND VGND gf180mcu_fd_sc_mcu7t5v0__fillcap_4
XFILLER_28_373 VPWR VPWR VGND VGND gf180mcu_fd_sc_mcu7t5v0__fillcap_4
XFILLER_38_148 VPWR VPWR VGND VGND gf180mcu_fd_sc_mcu7t5v0__fillcap_16
XFILLER_38_104 VPWR VPWR VGND VGND gf180mcu_fd_sc_mcu7t5v0__fill_1
XFILLER_34_321 VPWR VPWR VGND VGND gf180mcu_fd_sc_mcu7t5v0__fill_1
XFILLER_34_387 VPWR VPWR VGND VGND gf180mcu_fd_sc_mcu7t5v0__fillcap_4
XFILLER_22_527 VPWR VPWR VGND VGND gf180mcu_fd_sc_mcu7t5v0__fillcap_8
XPHY_EDGE_ROW_2_Right_2 VPWR VGND gf180mcu_fd_sc_mcu7t5v0__endcap
XFILLER_25_332 VPWR VPWR VGND VGND gf180mcu_fd_sc_mcu7t5v0__fill_2
XFILLER_25_376 VPWR VPWR VGND VGND gf180mcu_fd_sc_mcu7t5v0__fill_1
XTAP_TAPCELL_ROW_27_316 VPWR VGND gf180mcu_fd_sc_mcu7t5v0__filltie
XFILLER_4_247 VPWR VPWR VGND VGND gf180mcu_fd_sc_mcu7t5v0__fillcap_64
XFILLER_29_72 VPWR VPWR VGND VGND gf180mcu_fd_sc_mcu7t5v0__fillcap_64
X_596_ _596_/D _616_/CLK _596_/Q VPWR VPWR VGND VGND gf180mcu_fd_sc_mcu7t5v0__dffq_1
XFILLER_8_597 VPWR VPWR VGND VGND gf180mcu_fd_sc_mcu7t5v0__fillcap_8
XFILLER_20_2 VPWR VPWR VGND VGND gf180mcu_fd_sc_mcu7t5v0__fillcap_32
XFILLER_22_302 VPWR VPWR VGND VGND gf180mcu_fd_sc_mcu7t5v0__fillcap_4
XFILLER_26_107 VPWR VPWR VGND VGND gf180mcu_fd_sc_mcu7t5v0__fillcap_64
XTAP_TAPCELL_ROW_32_363 VPWR VGND gf180mcu_fd_sc_mcu7t5v0__filltie
XFILLER_1_206 VPWR VPWR VGND VGND gf180mcu_fd_sc_mcu7t5v0__fillcap_4
X_450_ _468_/A2 _453_/A2 _450_/A3 _450_/B _451_/B2 VPWR VPWR VGND VGND gf180mcu_fd_sc_mcu7t5v0__oai31_1
X_381_ _381_/A1 _379_/C _413_/B _409_/B VPWR VPWR VGND VGND gf180mcu_fd_sc_mcu7t5v0__nand3_2
XFILLER_5_556 VPWR VPWR VGND VGND gf180mcu_fd_sc_mcu7t5v0__fillcap_4
X_579_ _628_/Q _575_/Z _579_/B _628_/D VPWR VPWR VGND VGND gf180mcu_fd_sc_mcu7t5v0__aoi21_1
XFILLER_27_405 VPWR VPWR VGND VGND gf180mcu_fd_sc_mcu7t5v0__fillcap_8
XTAP_TAPCELL_ROW_9_169 VPWR VGND gf180mcu_fd_sc_mcu7t5v0__filltie
X_502_ input5/Z _510_/A2 _528_/A1 VPWR VPWR VGND VGND gf180mcu_fd_sc_mcu7t5v0__nand2_1
XFILLER_33_419 VPWR VPWR VGND VGND gf180mcu_fd_sc_mcu7t5v0__fill_1
XFILLER_18_427 VPWR VPWR VGND VGND gf180mcu_fd_sc_mcu7t5v0__fill_1
X_433_ _467_/C _351_/Z _433_/B _460_/B _434_/B VPWR VPWR VGND VGND gf180mcu_fd_sc_mcu7t5v0__oai211_2
X_295_ _295_/I _489_/A2 VPWR VPWR VGND VGND gf180mcu_fd_sc_mcu7t5v0__clkinv_1
XFILLER_9_136 VPWR VPWR VGND VGND gf180mcu_fd_sc_mcu7t5v0__fillcap_4
X_364_ _326_/B _364_/A2 _413_/B _370_/B _365_/A2 VPWR VPWR VGND VGND gf180mcu_fd_sc_mcu7t5v0__oai211_1
XFILLER_3_66 VPWR VPWR VGND VGND gf180mcu_fd_sc_mcu7t5v0__fillcap_4
Xwire39 _592_/Q uio_out[4] VPWR VPWR VGND VGND gf180mcu_fd_sc_mcu7t5v0__buf_3
XTAP_TAPCELL_ROW_6_139 VPWR VGND gf180mcu_fd_sc_mcu7t5v0__filltie
XFILLER_35_290 VPWR VPWR VGND VGND gf180mcu_fd_sc_mcu7t5v0__fillcap_4
XFILLER_37_72 VPWR VPWR VGND VGND gf180mcu_fd_sc_mcu7t5v0__fillcap_64
X_416_ _351_/Z _443_/B _444_/B _417_/B2 VPWR VPWR VGND VGND gf180mcu_fd_sc_mcu7t5v0__oai21_1
XTAP_TAPCELL_ROW_11_185 VPWR VGND gf180mcu_fd_sc_mcu7t5v0__filltie
X_347_ _310_/I _321_/I _445_/A2 VPWR VPWR VGND VGND gf180mcu_fd_sc_mcu7t5v0__nand2_2
XTAP_TAPCELL_ROW_19_252 VPWR VGND gf180mcu_fd_sc_mcu7t5v0__filltie
XFILLER_11_400 VPWR VPWR VGND VGND gf180mcu_fd_sc_mcu7t5v0__fillcap_4
XFILLER_11_422 VPWR VPWR VGND VGND gf180mcu_fd_sc_mcu7t5v0__fillcap_4
XFILLER_11_455 VPWR VPWR VGND VGND gf180mcu_fd_sc_mcu7t5v0__fillcap_32
XFILLER_23_293 VPWR VPWR VGND VGND gf180mcu_fd_sc_mcu7t5v0__fillcap_4
XFILLER_23_282 VPWR VPWR VGND VGND gf180mcu_fd_sc_mcu7t5v0__fill_1
XTAP_TAPCELL_ROW_25_299 VPWR VGND gf180mcu_fd_sc_mcu7t5v0__filltie
XFILLER_38_308 VPWR VPWR VGND VGND gf180mcu_fd_sc_mcu7t5v0__fill_2
XTAP_TAPCELL_ROW_16_222 VPWR VGND gf180mcu_fd_sc_mcu7t5v0__filltie
XFILLER_20_241 VPWR VPWR VGND VGND gf180mcu_fd_sc_mcu7t5v0__fillcap_4
XFILLER_20_296 VPWR VPWR VGND VGND gf180mcu_fd_sc_mcu7t5v0__fill_1
XFILLER_28_352 VPWR VPWR VGND VGND gf180mcu_fd_sc_mcu7t5v0__fill_2
XTAP_TAPCELL_ROW_13_203 VPWR VGND gf180mcu_fd_sc_mcu7t5v0__filltie
XFILLER_7_212 VPWR VPWR VGND VGND gf180mcu_fd_sc_mcu7t5v0__fillcap_64
XFILLER_38_138 VPWR VPWR VGND VGND gf180mcu_fd_sc_mcu7t5v0__fillcap_4
Xload_slew40 uio_out[3] _640_/I VPWR VPWR VGND VGND gf180mcu_fd_sc_mcu7t5v0__clkbuf_1
XFILLER_34_366 VPWR VPWR VGND VGND gf180mcu_fd_sc_mcu7t5v0__fillcap_16
XFILLER_19_352 VPWR VPWR VGND VGND gf180mcu_fd_sc_mcu7t5v0__fill_2
XFILLER_19_396 VPWR VPWR VGND VGND gf180mcu_fd_sc_mcu7t5v0__fill_2
XFILLER_22_506 VPWR VPWR VGND VGND gf180mcu_fd_sc_mcu7t5v0__fillcap_4
XFILLER_30_594 VPWR VPWR VGND VGND gf180mcu_fd_sc_mcu7t5v0__fill_1
XFILLER_25_344 VPWR VPWR VGND VGND gf180mcu_fd_sc_mcu7t5v0__fillcap_4
XTAP_TAPCELL_ROW_27_317 VPWR VGND gf180mcu_fd_sc_mcu7t5v0__filltie
XFILLER_21_594 VPWR VPWR VGND VGND gf180mcu_fd_sc_mcu7t5v0__fillcap_8
XFILLER_0_410 VPWR VPWR VGND VGND gf180mcu_fd_sc_mcu7t5v0__fillcap_32
X_595_ _595_/D _595_/CLK _595_/Q VPWR VPWR VGND VGND gf180mcu_fd_sc_mcu7t5v0__dffq_2
XFILLER_28_171 VPWR VPWR VGND VGND gf180mcu_fd_sc_mcu7t5v0__fillcap_4
XFILLER_8_521 VPWR VPWR VGND VGND gf180mcu_fd_sc_mcu7t5v0__fillcap_4
XFILLER_31_314 VPWR VPWR VGND VGND gf180mcu_fd_sc_mcu7t5v0__fillcap_4
XFILLER_13_2 VPWR VPWR VGND VGND gf180mcu_fd_sc_mcu7t5v0__fillcap_64
XTAP_TAPCELL_ROW_32_364 VPWR VGND gf180mcu_fd_sc_mcu7t5v0__filltie
XFILLER_13_347 VPWR VPWR VGND VGND gf180mcu_fd_sc_mcu7t5v0__fill_2
XFILLER_13_358 VPWR VPWR VGND VGND gf180mcu_fd_sc_mcu7t5v0__fill_1
X_380_ _379_/C _413_/B _472_/A2 VPWR VPWR VGND VGND gf180mcu_fd_sc_mcu7t5v0__nand2_1
XFILLER_0_240 VPWR VPWR VGND VGND gf180mcu_fd_sc_mcu7t5v0__fillcap_32
X_578_ _628_/Q _575_/Z _578_/B _579_/B VPWR VPWR VGND VGND gf180mcu_fd_sc_mcu7t5v0__oai21_1
.ends
