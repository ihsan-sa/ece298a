* NGSPICE file created from tt_um_r2r_dac_digital.ext - technology: gf180mcuD

* Black-box entry subcircuit for gf180mcu_fd_sc_mcu7t5v0__filltie abstract view
.subckt gf180mcu_fd_sc_mcu7t5v0__filltie VDD VSS
.ends

* Black-box entry subcircuit for gf180mcu_fd_sc_mcu7t5v0__fillcap_4 abstract view
.subckt gf180mcu_fd_sc_mcu7t5v0__fillcap_4 VDD VNW VPW VSS
.ends

* Black-box entry subcircuit for gf180mcu_fd_sc_mcu7t5v0__fillcap_64 abstract view
.subckt gf180mcu_fd_sc_mcu7t5v0__fillcap_64 VDD VNW VPW VSS
.ends

* Black-box entry subcircuit for gf180mcu_fd_sc_mcu7t5v0__nor3_1 abstract view
.subckt gf180mcu_fd_sc_mcu7t5v0__nor3_1 A1 A2 A3 ZN VDD VNW VPW VSS
.ends

* Black-box entry subcircuit for gf180mcu_fd_sc_mcu7t5v0__oai21_1 abstract view
.subckt gf180mcu_fd_sc_mcu7t5v0__oai21_1 A1 A2 B ZN VDD VNW VPW VSS
.ends

* Black-box entry subcircuit for gf180mcu_fd_sc_mcu7t5v0__aoi21_4 abstract view
.subckt gf180mcu_fd_sc_mcu7t5v0__aoi21_4 A1 A2 B ZN VDD VNW VPW VSS
.ends

* Black-box entry subcircuit for gf180mcu_fd_sc_mcu7t5v0__fill_1 abstract view
.subckt gf180mcu_fd_sc_mcu7t5v0__fill_1 VDD VNW VPW VSS
.ends

* Black-box entry subcircuit for gf180mcu_fd_sc_mcu7t5v0__fillcap_16 abstract view
.subckt gf180mcu_fd_sc_mcu7t5v0__fillcap_16 VDD VNW VPW VSS
.ends

* Black-box entry subcircuit for gf180mcu_fd_sc_mcu7t5v0__inv_2 abstract view
.subckt gf180mcu_fd_sc_mcu7t5v0__inv_2 I ZN VDD VNW VPW VSS
.ends

* Black-box entry subcircuit for gf180mcu_fd_sc_mcu7t5v0__aoi21_2 abstract view
.subckt gf180mcu_fd_sc_mcu7t5v0__aoi21_2 A1 A2 B ZN VDD VNW VPW VSS
.ends

* Black-box entry subcircuit for gf180mcu_fd_sc_mcu7t5v0__fill_2 abstract view
.subckt gf180mcu_fd_sc_mcu7t5v0__fill_2 VDD VNW VPW VSS
.ends

* Black-box entry subcircuit for gf180mcu_fd_sc_mcu7t5v0__endcap abstract view
.subckt gf180mcu_fd_sc_mcu7t5v0__endcap VDD VSS
.ends

* Black-box entry subcircuit for gf180mcu_fd_sc_mcu7t5v0__buf_4 abstract view
.subckt gf180mcu_fd_sc_mcu7t5v0__buf_4 I Z VDD VNW VPW VSS
.ends

* Black-box entry subcircuit for gf180mcu_fd_sc_mcu7t5v0__buf_8 abstract view
.subckt gf180mcu_fd_sc_mcu7t5v0__buf_8 I Z VDD VNW VPW VSS
.ends

* Black-box entry subcircuit for gf180mcu_fd_sc_mcu7t5v0__buf_2 abstract view
.subckt gf180mcu_fd_sc_mcu7t5v0__buf_2 I Z VDD VNW VPW VSS
.ends

* Black-box entry subcircuit for gf180mcu_fd_sc_mcu7t5v0__fillcap_32 abstract view
.subckt gf180mcu_fd_sc_mcu7t5v0__fillcap_32 VDD VNW VPW VSS
.ends

* Black-box entry subcircuit for gf180mcu_fd_sc_mcu7t5v0__nand2_1 abstract view
.subckt gf180mcu_fd_sc_mcu7t5v0__nand2_1 A1 A2 ZN VDD VNW VPW VSS
.ends

* Black-box entry subcircuit for gf180mcu_fd_sc_mcu7t5v0__aoi22_1 abstract view
.subckt gf180mcu_fd_sc_mcu7t5v0__aoi22_1 A1 A2 B1 B2 ZN VDD VNW VPW VSS
.ends

* Black-box entry subcircuit for gf180mcu_fd_sc_mcu7t5v0__dffq_1 abstract view
.subckt gf180mcu_fd_sc_mcu7t5v0__dffq_1 D CLK Q VDD VNW VPW VSS
.ends

* Black-box entry subcircuit for gf180mcu_fd_sc_mcu7t5v0__aoi221_1 abstract view
.subckt gf180mcu_fd_sc_mcu7t5v0__aoi221_1 A1 A2 B1 B2 C ZN VDD VNW VPW VSS
.ends

* Black-box entry subcircuit for gf180mcu_fd_sc_mcu7t5v0__clkbuf_8 abstract view
.subckt gf180mcu_fd_sc_mcu7t5v0__clkbuf_8 I Z VDD VNW VPW VSS
.ends

* Black-box entry subcircuit for gf180mcu_fd_sc_mcu7t5v0__fillcap_8 abstract view
.subckt gf180mcu_fd_sc_mcu7t5v0__fillcap_8 VDD VNW VPW VSS
.ends

* Black-box entry subcircuit for gf180mcu_fd_sc_mcu7t5v0__dffq_2 abstract view
.subckt gf180mcu_fd_sc_mcu7t5v0__dffq_2 D CLK Q VDD VNW VPW VSS
.ends

* Black-box entry subcircuit for gf180mcu_fd_sc_mcu7t5v0__aoi211_4 abstract view
.subckt gf180mcu_fd_sc_mcu7t5v0__aoi211_4 A1 A2 B C ZN VDD VNW VPW VSS
.ends

* Black-box entry subcircuit for gf180mcu_fd_sc_mcu7t5v0__nand3_2 abstract view
.subckt gf180mcu_fd_sc_mcu7t5v0__nand3_2 A1 A2 A3 ZN VDD VNW VPW VSS
.ends

* Black-box entry subcircuit for gf180mcu_fd_sc_mcu7t5v0__nand4_4 abstract view
.subckt gf180mcu_fd_sc_mcu7t5v0__nand4_4 A1 A2 A3 A4 ZN VDD VNW VPW VSS
.ends

* Black-box entry subcircuit for gf180mcu_fd_sc_mcu7t5v0__aoi21_1 abstract view
.subckt gf180mcu_fd_sc_mcu7t5v0__aoi21_1 A1 A2 B ZN VDD VNW VPW VSS
.ends

* Black-box entry subcircuit for gf180mcu_fd_sc_mcu7t5v0__and4_1 abstract view
.subckt gf180mcu_fd_sc_mcu7t5v0__and4_1 A1 A2 A3 A4 Z VDD VNW VPW VSS
.ends

* Black-box entry subcircuit for gf180mcu_fd_sc_mcu7t5v0__dffq_4 abstract view
.subckt gf180mcu_fd_sc_mcu7t5v0__dffq_4 D CLK Q VDD VNW VPW VSS
.ends

* Black-box entry subcircuit for gf180mcu_fd_sc_mcu7t5v0__or2_2 abstract view
.subckt gf180mcu_fd_sc_mcu7t5v0__or2_2 A1 A2 Z VDD VNW VPW VSS
.ends

* Black-box entry subcircuit for gf180mcu_fd_sc_mcu7t5v0__and4_2 abstract view
.subckt gf180mcu_fd_sc_mcu7t5v0__and4_2 A1 A2 A3 A4 Z VDD VNW VPW VSS
.ends

* Black-box entry subcircuit for gf180mcu_fd_sc_mcu7t5v0__inv_8 abstract view
.subckt gf180mcu_fd_sc_mcu7t5v0__inv_8 I ZN VDD VNW VPW VSS
.ends

* Black-box entry subcircuit for gf180mcu_fd_sc_mcu7t5v0__nand2_2 abstract view
.subckt gf180mcu_fd_sc_mcu7t5v0__nand2_2 A1 A2 ZN VDD VNW VPW VSS
.ends

* Black-box entry subcircuit for gf180mcu_fd_sc_mcu7t5v0__nand3_1 abstract view
.subckt gf180mcu_fd_sc_mcu7t5v0__nand3_1 A1 A2 A3 ZN VDD VNW VPW VSS
.ends

* Black-box entry subcircuit for gf180mcu_fd_sc_mcu7t5v0__clkinv_1 abstract view
.subckt gf180mcu_fd_sc_mcu7t5v0__clkinv_1 I ZN VDD VNW VPW VSS
.ends

* Black-box entry subcircuit for gf180mcu_fd_sc_mcu7t5v0__oai211_4 abstract view
.subckt gf180mcu_fd_sc_mcu7t5v0__oai211_4 A1 A2 B C ZN VDD VNW VPW VSS
.ends

* Black-box entry subcircuit for gf180mcu_fd_sc_mcu7t5v0__nor2_4 abstract view
.subckt gf180mcu_fd_sc_mcu7t5v0__nor2_4 A1 A2 ZN VDD VNW VPW VSS
.ends

* Black-box entry subcircuit for gf180mcu_fd_sc_mcu7t5v0__nor2_1 abstract view
.subckt gf180mcu_fd_sc_mcu7t5v0__nor2_1 A1 A2 ZN VDD VNW VPW VSS
.ends

* Black-box entry subcircuit for gf180mcu_fd_sc_mcu7t5v0__and4_4 abstract view
.subckt gf180mcu_fd_sc_mcu7t5v0__and4_4 A1 A2 A3 A4 Z VDD VNW VPW VSS
.ends

* Black-box entry subcircuit for gf180mcu_fd_sc_mcu7t5v0__buf_1 abstract view
.subckt gf180mcu_fd_sc_mcu7t5v0__buf_1 I Z VDD VNW VPW VSS
.ends

* Black-box entry subcircuit for gf180mcu_fd_sc_mcu7t5v0__nand2_4 abstract view
.subckt gf180mcu_fd_sc_mcu7t5v0__nand2_4 A1 A2 ZN VDD VNW VPW VSS
.ends

* Black-box entry subcircuit for gf180mcu_fd_sc_mcu7t5v0__oai211_1 abstract view
.subckt gf180mcu_fd_sc_mcu7t5v0__oai211_1 A1 A2 B C ZN VDD VNW VPW VSS
.ends

* Black-box entry subcircuit for gf180mcu_fd_sc_mcu7t5v0__aoi22_2 abstract view
.subckt gf180mcu_fd_sc_mcu7t5v0__aoi22_2 A1 A2 B1 B2 ZN VDD VNW VPW VSS
.ends

* Black-box entry subcircuit for gf180mcu_fd_sc_mcu7t5v0__clkbuf_1 abstract view
.subckt gf180mcu_fd_sc_mcu7t5v0__clkbuf_1 I Z VDD VNW VPW VSS
.ends

* Black-box entry subcircuit for gf180mcu_fd_sc_mcu7t5v0__buf_3 abstract view
.subckt gf180mcu_fd_sc_mcu7t5v0__buf_3 I Z VDD VNW VPW VSS
.ends

* Black-box entry subcircuit for gf180mcu_fd_sc_mcu7t5v0__and2_1 abstract view
.subckt gf180mcu_fd_sc_mcu7t5v0__and2_1 A1 A2 Z VDD VNW VPW VSS
.ends

* Black-box entry subcircuit for gf180mcu_fd_sc_mcu7t5v0__oai221_2 abstract view
.subckt gf180mcu_fd_sc_mcu7t5v0__oai221_2 A1 A2 B1 B2 C ZN VDD VNW VPW VSS
.ends

* Black-box entry subcircuit for gf180mcu_fd_sc_mcu7t5v0__oai31_1 abstract view
.subckt gf180mcu_fd_sc_mcu7t5v0__oai31_1 A1 A2 A3 B ZN VDD VNW VPW VSS
.ends

* Black-box entry subcircuit for gf180mcu_fd_sc_mcu7t5v0__oai21_2 abstract view
.subckt gf180mcu_fd_sc_mcu7t5v0__oai21_2 A1 A2 B ZN VDD VNW VPW VSS
.ends

* Black-box entry subcircuit for gf180mcu_fd_sc_mcu7t5v0__or2_1 abstract view
.subckt gf180mcu_fd_sc_mcu7t5v0__or2_1 A1 A2 Z VDD VNW VPW VSS
.ends

* Black-box entry subcircuit for gf180mcu_fd_sc_mcu7t5v0__buf_12 abstract view
.subckt gf180mcu_fd_sc_mcu7t5v0__buf_12 I Z VDD VNW VPW VSS
.ends

* Black-box entry subcircuit for gf180mcu_fd_sc_mcu7t5v0__aoi221_4 abstract view
.subckt gf180mcu_fd_sc_mcu7t5v0__aoi221_4 A1 A2 B1 B2 C ZN VDD VNW VPW VSS
.ends

* Black-box entry subcircuit for gf180mcu_fd_sc_mcu7t5v0__nor4_4 abstract view
.subckt gf180mcu_fd_sc_mcu7t5v0__nor4_4 A1 A2 A3 A4 ZN VDD VNW VPW VSS
.ends

* Black-box entry subcircuit for gf180mcu_fd_sc_mcu7t5v0__aoi211_2 abstract view
.subckt gf180mcu_fd_sc_mcu7t5v0__aoi211_2 A1 A2 B C ZN VDD VNW VPW VSS
.ends

* Black-box entry subcircuit for gf180mcu_fd_sc_mcu7t5v0__oai21_4 abstract view
.subckt gf180mcu_fd_sc_mcu7t5v0__oai21_4 A1 A2 B ZN VDD VNW VPW VSS
.ends

* Black-box entry subcircuit for gf180mcu_fd_sc_mcu7t5v0__oai22_4 abstract view
.subckt gf180mcu_fd_sc_mcu7t5v0__oai22_4 A1 A2 B1 B2 ZN VDD VNW VPW VSS
.ends

* Black-box entry subcircuit for gf180mcu_fd_sc_mcu7t5v0__aoi22_4 abstract view
.subckt gf180mcu_fd_sc_mcu7t5v0__aoi22_4 A1 A2 B1 B2 ZN VDD VNW VPW VSS
.ends

* Black-box entry subcircuit for gf180mcu_fd_sc_mcu7t5v0__nand3_4 abstract view
.subckt gf180mcu_fd_sc_mcu7t5v0__nand3_4 A1 A2 A3 ZN VDD VNW VPW VSS
.ends

* Black-box entry subcircuit for gf180mcu_fd_sc_mcu7t5v0__oai32_4 abstract view
.subckt gf180mcu_fd_sc_mcu7t5v0__oai32_4 A1 A2 A3 B1 B2 ZN VDD VNW VPW VSS
.ends

* Black-box entry subcircuit for gf180mcu_fd_sc_mcu7t5v0__oai211_2 abstract view
.subckt gf180mcu_fd_sc_mcu7t5v0__oai211_2 A1 A2 B C ZN VDD VNW VPW VSS
.ends

* Black-box entry subcircuit for gf180mcu_fd_sc_mcu7t5v0__tieh abstract view
.subckt gf180mcu_fd_sc_mcu7t5v0__tieh Z VDD VNW VPW VSS
.ends

* Black-box entry subcircuit for gf180mcu_fd_sc_mcu7t5v0__clkinv_16 abstract view
.subckt gf180mcu_fd_sc_mcu7t5v0__clkinv_16 I ZN VDD VNW VPW VSS
.ends

* Black-box entry subcircuit for gf180mcu_fd_sc_mcu7t5v0__clkinv_4 abstract view
.subckt gf180mcu_fd_sc_mcu7t5v0__clkinv_4 I ZN VDD VNW VPW VSS
.ends

* Black-box entry subcircuit for gf180mcu_fd_sc_mcu7t5v0__clkinv_2 abstract view
.subckt gf180mcu_fd_sc_mcu7t5v0__clkinv_2 I ZN VDD VNW VPW VSS
.ends

* Black-box entry subcircuit for gf180mcu_fd_sc_mcu7t5v0__oai31_4 abstract view
.subckt gf180mcu_fd_sc_mcu7t5v0__oai31_4 A1 A2 A3 B ZN VDD VNW VPW VSS
.ends

* Black-box entry subcircuit for gf180mcu_fd_sc_mcu7t5v0__xor2_2 abstract view
.subckt gf180mcu_fd_sc_mcu7t5v0__xor2_2 A1 A2 Z VDD VNW VPW VSS
.ends

* Black-box entry subcircuit for gf180mcu_fd_sc_mcu7t5v0__buf_16 abstract view
.subckt gf180mcu_fd_sc_mcu7t5v0__buf_16 I Z VDD VNW VPW VSS
.ends

* Black-box entry subcircuit for gf180mcu_fd_sc_mcu7t5v0__and2_4 abstract view
.subckt gf180mcu_fd_sc_mcu7t5v0__and2_4 A1 A2 Z VDD VNW VPW VSS
.ends

* Black-box entry subcircuit for gf180mcu_fd_sc_mcu7t5v0__inv_4 abstract view
.subckt gf180mcu_fd_sc_mcu7t5v0__inv_4 I ZN VDD VNW VPW VSS
.ends

* Black-box entry subcircuit for gf180mcu_fd_sc_mcu7t5v0__nand4_2 abstract view
.subckt gf180mcu_fd_sc_mcu7t5v0__nand4_2 A1 A2 A3 A4 ZN VDD VNW VPW VSS
.ends

* Black-box entry subcircuit for gf180mcu_fd_sc_mcu7t5v0__nor2_2 abstract view
.subckt gf180mcu_fd_sc_mcu7t5v0__nor2_2 A1 A2 ZN VDD VNW VPW VSS
.ends

* Black-box entry subcircuit for gf180mcu_fd_sc_mcu7t5v0__mux2_2 abstract view
.subckt gf180mcu_fd_sc_mcu7t5v0__mux2_2 I0 I1 S Z VDD VNW VPW VSS
.ends

* Black-box entry subcircuit for gf180mcu_fd_sc_mcu7t5v0__xor2_1 abstract view
.subckt gf180mcu_fd_sc_mcu7t5v0__xor2_1 A1 A2 Z VDD VNW VPW VSS
.ends

* Black-box entry subcircuit for gf180mcu_fd_sc_mcu7t5v0__clkinv_8 abstract view
.subckt gf180mcu_fd_sc_mcu7t5v0__clkinv_8 I ZN VDD VNW VPW VSS
.ends

* Black-box entry subcircuit for gf180mcu_fd_sc_mcu7t5v0__nor3_4 abstract view
.subckt gf180mcu_fd_sc_mcu7t5v0__nor3_4 A1 A2 A3 ZN VDD VNW VPW VSS
.ends

* Black-box entry subcircuit for gf180mcu_fd_sc_mcu7t5v0__oai31_2 abstract view
.subckt gf180mcu_fd_sc_mcu7t5v0__oai31_2 A1 A2 A3 B ZN VDD VNW VPW VSS
.ends

* Black-box entry subcircuit for gf180mcu_fd_sc_mcu7t5v0__nand4_1 abstract view
.subckt gf180mcu_fd_sc_mcu7t5v0__nand4_1 A1 A2 A3 A4 ZN VDD VNW VPW VSS
.ends

* Black-box entry subcircuit for gf180mcu_fd_sc_mcu7t5v0__oai221_1 abstract view
.subckt gf180mcu_fd_sc_mcu7t5v0__oai221_1 A1 A2 B1 B2 C ZN VDD VNW VPW VSS
.ends

* Black-box entry subcircuit for gf180mcu_fd_sc_mcu7t5v0__clkbuf_4 abstract view
.subckt gf180mcu_fd_sc_mcu7t5v0__clkbuf_4 I Z VDD VNW VPW VSS
.ends

.subckt tt_um_r2r_dac_digital VGND VPWR clk ena rst_n ui_in[0] ui_in[1] ui_in[2] ui_in[3]
+ ui_in[4] ui_in[5] ui_in[6] ui_in[7] uio_in[0] uio_in[1] uio_in[2] uio_in[3] uio_in[4]
+ uio_in[5] uio_in[6] uio_in[7] uio_oe[0] uio_oe[1] uio_oe[2] uio_oe[3] uio_oe[4]
+ uio_oe[5] uio_oe[6] uio_oe[7] uio_out[0] uio_out[1] uio_out[2] uio_out[3] uio_out[4]
+ uio_out[5] uio_out[6] uio_out[7] uo_out[0] uo_out[1] uo_out[2] uo_out[3] uo_out[4]
+ uo_out[5] uo_out[6] uo_out[7]
XTAP_TAPCELL_ROW_37_401 VPWR VGND gf180mcu_fd_sc_mcu7t5v0__filltie
XFILLER_10_317 VPWR VPWR VGND VGND gf180mcu_fd_sc_mcu7t5v0__fillcap_4
XFILLER_22_177 VPWR VPWR VGND VGND gf180mcu_fd_sc_mcu7t5v0__fillcap_64
XFILLER_2_527 VPWR VPWR VGND VGND gf180mcu_fd_sc_mcu7t5v0__fillcap_64
X_501_ _488_/C _414_/C _516_/A1 _502_/A2 VPWR VPWR VGND VGND gf180mcu_fd_sc_mcu7t5v0__nor3_1
X_432_ _432_/A1 _432_/A2 _432_/B _618_/D VPWR VPWR VGND VGND gf180mcu_fd_sc_mcu7t5v0__oai21_1
X_363_ _363_/A1 _642_/Q _643_/Q wire67/I VPWR VPWR VGND VGND gf180mcu_fd_sc_mcu7t5v0__aoi21_4
XFILLER_5_376 VPWR VPWR VGND VGND gf180mcu_fd_sc_mcu7t5v0__fill_1
XFILLER_36_247 VPWR VPWR VGND VGND gf180mcu_fd_sc_mcu7t5v0__fillcap_4
XFILLER_36_225 VPWR VPWR VGND VGND gf180mcu_fd_sc_mcu7t5v0__fillcap_4
XFILLER_6_107 VPWR VPWR VGND VGND gf180mcu_fd_sc_mcu7t5v0__fillcap_64
XFILLER_11_604 VPWR VPWR VGND VGND gf180mcu_fd_sc_mcu7t5v0__fill_1
XFILLER_18_247 VPWR VPWR VGND VGND gf180mcu_fd_sc_mcu7t5v0__fillcap_16
X_346_ _544_/B _649_/D VPWR VPWR VGND VGND gf180mcu_fd_sc_mcu7t5v0__inv_2
X_415_ _454_/B _478_/A1 _415_/B _417_/A2 VPWR VPWR VGND VGND gf180mcu_fd_sc_mcu7t5v0__aoi21_2
XFILLER_18_269 VPWR VPWR VGND VGND gf180mcu_fd_sc_mcu7t5v0__fill_1
XFILLER_33_206 VPWR VPWR VGND VGND gf180mcu_fd_sc_mcu7t5v0__fillcap_4
XTAP_TAPCELL_ROW_11_186 VPWR VGND gf180mcu_fd_sc_mcu7t5v0__filltie
XTAP_TAPCELL_ROW_19_253 VPWR VGND gf180mcu_fd_sc_mcu7t5v0__filltie
XFILLER_32_283 VPWR VPWR VGND VGND gf180mcu_fd_sc_mcu7t5v0__fill_2
XTAP_TAPCELL_ROW_2_110 VPWR VGND gf180mcu_fd_sc_mcu7t5v0__filltie
XFILLER_15_206 VPWR VPWR VGND VGND gf180mcu_fd_sc_mcu7t5v0__fillcap_4
XFILLER_11_489 VPWR VPWR VGND VGND gf180mcu_fd_sc_mcu7t5v0__fill_1
XTAP_TAPCELL_ROW_16_223 VPWR VGND gf180mcu_fd_sc_mcu7t5v0__filltie
XFILLER_9_66 VPWR VPWR VGND VGND gf180mcu_fd_sc_mcu7t5v0__fillcap_4
X_329_ _657_/Q _327_/Z _329_/B _370_/A2 VPWR VPWR VGND VGND gf180mcu_fd_sc_mcu7t5v0__aoi21_4
XFILLER_25_559 VPWR VPWR VGND VGND gf180mcu_fd_sc_mcu7t5v0__fill_1
XFILLER_20_275 VPWR VPWR VGND VGND gf180mcu_fd_sc_mcu7t5v0__fill_1
XPHY_EDGE_ROW_8_Left_47 VPWR VGND gf180mcu_fd_sc_mcu7t5v0__endcap
XFILLER_28_331 VPWR VPWR VGND VGND gf180mcu_fd_sc_mcu7t5v0__fill_1
XTAP_TAPCELL_ROW_13_204 VPWR VGND gf180mcu_fd_sc_mcu7t5v0__filltie
XTAP_TAPCELL_ROW_21_270 VPWR VGND gf180mcu_fd_sc_mcu7t5v0__filltie
XFILLER_38_117 VPWR VPWR VGND VGND gf180mcu_fd_sc_mcu7t5v0__fill_1
Xload_slew74 uio_out[6] _672_/I VPWR VPWR VGND VGND gf180mcu_fd_sc_mcu7t5v0__buf_4
Xload_slew52 _454_/A1 _425_/A2 VPWR VPWR VGND VGND gf180mcu_fd_sc_mcu7t5v0__buf_8
Xload_slew30 _443_/A3 _474_/A2 VPWR VPWR VGND VGND gf180mcu_fd_sc_mcu7t5v0__buf_2
Xload_slew63 _433_/A3 _391_/A2 VPWR VPWR VGND VGND gf180mcu_fd_sc_mcu7t5v0__buf_4
XTAP_TAPCELL_ROW_27_318 VPWR VGND gf180mcu_fd_sc_mcu7t5v0__filltie
XTAP_TAPCELL_ROW_35_384 VPWR VGND gf180mcu_fd_sc_mcu7t5v0__filltie
XFILLER_0_444 VPWR VPWR VGND VGND gf180mcu_fd_sc_mcu7t5v0__fillcap_32
X_594_ _637_/Q _602_/A2 _595_/A2 VPWR VPWR VGND VGND gf180mcu_fd_sc_mcu7t5v0__nand2_1
XFILLER_8_522 VPWR VPWR VGND VGND gf180mcu_fd_sc_mcu7t5v0__fill_2
XFILLER_6_34 VPWR VPWR VGND VGND gf180mcu_fd_sc_mcu7t5v0__fill_1
XFILLER_12_573 VPWR VPWR VGND VGND gf180mcu_fd_sc_mcu7t5v0__fillcap_16
XFILLER_31_348 VPWR VPWR VGND VGND gf180mcu_fd_sc_mcu7t5v0__fill_2
XFILLER_3_282 VPWR VPWR VGND VGND gf180mcu_fd_sc_mcu7t5v0__fillcap_64
XTAP_TAPCELL_ROW_32_365 VPWR VGND gf180mcu_fd_sc_mcu7t5v0__filltie
Xrebuffer107 wire70/Z _382_/A2 VPWR VPWR VGND VGND gf180mcu_fd_sc_mcu7t5v0__buf_8
Xrebuffer129 _330_/A2 _549_/A2 VPWR VPWR VGND VGND gf180mcu_fd_sc_mcu7t5v0__buf_8
XFILLER_13_315 VPWR VPWR VGND VGND gf180mcu_fd_sc_mcu7t5v0__fill_1
XFILLER_25_142 VPWR VPWR VGND VGND gf180mcu_fd_sc_mcu7t5v0__fillcap_64
XFILLER_0_274 VPWR VPWR VGND VGND gf180mcu_fd_sc_mcu7t5v0__fillcap_32
X_577_ _623_/Q _585_/A2 _585_/B1 _647_/Q _579_/A1 VPWR VPWR VGND VGND gf180mcu_fd_sc_mcu7t5v0__aoi22_1
X_646_ _646_/D _646_/CLK _646_/Q VPWR VPWR VGND VGND gf180mcu_fd_sc_mcu7t5v0__dffq_1
XFILLER_4_591 VPWR VPWR VGND VGND gf180mcu_fd_sc_mcu7t5v0__fillcap_4
XTAP_TAPCELL_ROW_37_402 VPWR VGND gf180mcu_fd_sc_mcu7t5v0__filltie
XFILLER_22_101 VPWR VPWR VGND VGND gf180mcu_fd_sc_mcu7t5v0__fillcap_4
X_500_ _506_/A1 _407_/B _500_/B1 _522_/A3 _505_/C _502_/A1 VPWR VPWR VGND VGND gf180mcu_fd_sc_mcu7t5v0__aoi221_1
XPHY_EDGE_ROW_37_Left_76 VPWR VGND gf180mcu_fd_sc_mcu7t5v0__endcap
X_431_ _513_/B2 _431_/A2 _432_/A2 VPWR VPWR VGND VGND gf180mcu_fd_sc_mcu7t5v0__nand2_1
X_362_ _642_/Q _382_/A2 _375_/C VPWR VPWR VGND VGND gf180mcu_fd_sc_mcu7t5v0__nand2_1
Xclkbuf_3_6__f_clk clkbuf_0_clk/Z _646_/CLK VPWR VPWR VGND VGND gf180mcu_fd_sc_mcu7t5v0__clkbuf_8
XTAP_TAPCELL_ROW_8_160 VPWR VGND gf180mcu_fd_sc_mcu7t5v0__filltie
XFILLER_1_594 VPWR VPWR VGND VGND gf180mcu_fd_sc_mcu7t5v0__fillcap_8
X_629_ _629_/D _645_/CLK _629_/Q VPWR VPWR VGND VGND gf180mcu_fd_sc_mcu7t5v0__dffq_2
XFILLER_8_171 VPWR VPWR VGND VGND gf180mcu_fd_sc_mcu7t5v0__fillcap_4
XTAP_TAPCELL_ROW_5_130 VPWR VGND gf180mcu_fd_sc_mcu7t5v0__filltie
XFILLER_14_454 VPWR VPWR VGND VGND gf180mcu_fd_sc_mcu7t5v0__fill_1
X_414_ _439_/A1 _449_/A3 _414_/B _414_/C _415_/B VPWR VPWR VGND VGND gf180mcu_fd_sc_mcu7t5v0__aoi211_4
X_345_ _344_/Z _345_/A2 _400_/C _345_/ZN VPWR VPWR VGND VGND gf180mcu_fd_sc_mcu7t5v0__nand3_2
XTAP_TAPCELL_ROW_11_187 VPWR VGND gf180mcu_fd_sc_mcu7t5v0__filltie
XTAP_TAPCELL_ROW_19_254 VPWR VGND gf180mcu_fd_sc_mcu7t5v0__filltie
XPHY_EDGE_ROW_12_Right_12 VPWR VGND gf180mcu_fd_sc_mcu7t5v0__endcap
XTAP_TAPCELL_ROW_2_111 VPWR VGND gf180mcu_fd_sc_mcu7t5v0__filltie
XPHY_EDGE_ROW_21_Right_21 VPWR VGND gf180mcu_fd_sc_mcu7t5v0__endcap
XPHY_EDGE_ROW_30_Right_30 VPWR VGND gf180mcu_fd_sc_mcu7t5v0__endcap
XFILLER_3_2 VPWR VPWR VGND VGND gf180mcu_fd_sc_mcu7t5v0__fillcap_64
XFILLER_2_177 VPWR VPWR VGND VGND gf180mcu_fd_sc_mcu7t5v0__fillcap_64
XFILLER_0_36 VPWR VPWR VGND VGND gf180mcu_fd_sc_mcu7t5v0__fillcap_32
XTAP_TAPCELL_ROW_16_224 VPWR VGND gf180mcu_fd_sc_mcu7t5v0__filltie
XTAP_TAPCELL_ROW_24_290 VPWR VGND gf180mcu_fd_sc_mcu7t5v0__filltie
X_328_ _654_/Q _325_/Z _656_/Q _655_/Q _330_/A2 VPWR VPWR VGND VGND gf180mcu_fd_sc_mcu7t5v0__nand4_4
XFILLER_36_2 VPWR VPWR VGND VGND gf180mcu_fd_sc_mcu7t5v0__fillcap_32
XPHY_EDGE_ROW_24_Left_63 VPWR VGND gf180mcu_fd_sc_mcu7t5v0__endcap
XTAP_TAPCELL_ROW_0_90 VPWR VGND gf180mcu_fd_sc_mcu7t5v0__filltie
XFILLER_0_604 VPWR VPWR VGND VGND gf180mcu_fd_sc_mcu7t5v0__fill_1
XFILLER_11_276 VPWR VPWR VGND VGND gf180mcu_fd_sc_mcu7t5v0__fillcap_4
XTAP_TAPCELL_ROW_21_271 VPWR VGND gf180mcu_fd_sc_mcu7t5v0__filltie
XFILLER_3_486 VPWR VPWR VGND VGND gf180mcu_fd_sc_mcu7t5v0__fillcap_4
Xload_slew86 uio_out[0] _666_/I VPWR VPWR VGND VGND gf180mcu_fd_sc_mcu7t5v0__buf_4
XTAP_TAPCELL_ROW_27_319 VPWR VGND gf180mcu_fd_sc_mcu7t5v0__filltie
XTAP_TAPCELL_ROW_35_385 VPWR VGND gf180mcu_fd_sc_mcu7t5v0__filltie
XFILLER_0_478 VPWR VPWR VGND VGND gf180mcu_fd_sc_mcu7t5v0__fillcap_32
X_593_ _593_/A1 _593_/A2 _601_/B _636_/D VPWR VPWR VGND VGND gf180mcu_fd_sc_mcu7t5v0__aoi21_1
XFILLER_12_541 VPWR VPWR VGND VGND gf180mcu_fd_sc_mcu7t5v0__fillcap_32
Xrebuffer119 wire28/Z _454_/C VPWR VPWR VGND VGND gf180mcu_fd_sc_mcu7t5v0__buf_8
Xrebuffer108 _360_/I _506_/B VPWR VPWR VGND VGND gf180mcu_fd_sc_mcu7t5v0__buf_8
XTAP_TAPCELL_ROW_32_366 VPWR VGND gf180mcu_fd_sc_mcu7t5v0__filltie
XPHY_EDGE_ROW_6_Right_6 VPWR VGND gf180mcu_fd_sc_mcu7t5v0__endcap
XPHY_EDGE_ROW_11_Left_50 VPWR VGND gf180mcu_fd_sc_mcu7t5v0__endcap
XFILLER_15_66 VPWR VPWR VGND VGND gf180mcu_fd_sc_mcu7t5v0__fillcap_4
X_645_ _645_/D _645_/CLK _645_/Q VPWR VPWR VGND VGND gf180mcu_fd_sc_mcu7t5v0__dffq_2
X_576_ input7/Z _582_/B1 _599_/A1 VPWR VPWR VGND VGND gf180mcu_fd_sc_mcu7t5v0__nand2_1
XTAP_TAPCELL_ROW_37_403 VPWR VGND gf180mcu_fd_sc_mcu7t5v0__filltie
XFILLER_23_603 VPWR VPWR VGND VGND gf180mcu_fd_sc_mcu7t5v0__fill_2
XFILLER_35_474 VPWR VPWR VGND VGND gf180mcu_fd_sc_mcu7t5v0__fill_2
X_361_ _355_/B _400_/C _361_/A3 _361_/A4 _421_/C VPWR VPWR VGND VGND gf180mcu_fd_sc_mcu7t5v0__and4_1
X_430_ _430_/A1 _432_/A1 _649_/D _432_/B VPWR VPWR VGND VGND gf180mcu_fd_sc_mcu7t5v0__oai21_1
XTAP_TAPCELL_ROW_8_161 VPWR VGND gf180mcu_fd_sc_mcu7t5v0__filltie
XFILLER_1_562 VPWR VPWR VGND VGND gf180mcu_fd_sc_mcu7t5v0__fillcap_32
X_628_ _628_/D _633_/CLK _628_/Q VPWR VPWR VGND VGND gf180mcu_fd_sc_mcu7t5v0__dffq_4
X_559_ _559_/A1 _559_/A2 _559_/B _626_/D VPWR VPWR VGND VGND gf180mcu_fd_sc_mcu7t5v0__aoi21_2
XFILLER_35_282 VPWR VPWR VGND VGND gf180mcu_fd_sc_mcu7t5v0__fill_2
XFILLER_12_34 VPWR VPWR VGND VGND gf180mcu_fd_sc_mcu7t5v0__fill_1
XTAP_TAPCELL_ROW_5_131 VPWR VGND gf180mcu_fd_sc_mcu7t5v0__filltie
X_413_ wire46/Z _407_/B _645_/D _532_/B VPWR VPWR VGND VGND gf180mcu_fd_sc_mcu7t5v0__aoi21_4
X_344_ _344_/A1 _351_/A1 _344_/Z VPWR VPWR VGND VGND gf180mcu_fd_sc_mcu7t5v0__or2_2
XFILLER_5_142 VPWR VPWR VGND VGND gf180mcu_fd_sc_mcu7t5v0__fillcap_64
XTAP_TAPCELL_ROW_19_255 VPWR VGND gf180mcu_fd_sc_mcu7t5v0__filltie
XFILLER_32_241 VPWR VPWR VGND VGND gf180mcu_fd_sc_mcu7t5v0__fillcap_4
XFILLER_9_492 VPWR VPWR VGND VGND gf180mcu_fd_sc_mcu7t5v0__fillcap_64
XFILLER_32_285 VPWR VPWR VGND VGND gf180mcu_fd_sc_mcu7t5v0__fill_1
XFILLER_23_66 VPWR VPWR VGND VGND gf180mcu_fd_sc_mcu7t5v0__fillcap_4
XFILLER_3_602 VPWR VPWR VGND VGND gf180mcu_fd_sc_mcu7t5v0__fill_2
XFILLER_2_101 VPWR VPWR VGND VGND gf180mcu_fd_sc_mcu7t5v0__fillcap_4
XFILLER_14_241 VPWR VPWR VGND VGND gf180mcu_fd_sc_mcu7t5v0__fillcap_4
XFILLER_14_263 VPWR VPWR VGND VGND gf180mcu_fd_sc_mcu7t5v0__fillcap_8
XTAP_TAPCELL_ROW_16_225 VPWR VGND gf180mcu_fd_sc_mcu7t5v0__filltie
XTAP_TAPCELL_ROW_24_291 VPWR VGND gf180mcu_fd_sc_mcu7t5v0__filltie
X_327_ _654_/Q _655_/Q _656_/Q _325_/Z _327_/Z VPWR VPWR VGND VGND gf180mcu_fd_sc_mcu7t5v0__and4_2
XTAP_TAPCELL_ROW_0_80 VPWR VGND gf180mcu_fd_sc_mcu7t5v0__filltie
XTAP_TAPCELL_ROW_0_91 VPWR VGND gf180mcu_fd_sc_mcu7t5v0__filltie
XFILLER_29_2 VPWR VPWR VGND VGND gf180mcu_fd_sc_mcu7t5v0__fillcap_64
XTAP_TAPCELL_ROW_21_272 VPWR VGND gf180mcu_fd_sc_mcu7t5v0__filltie
Xload_slew54 wire55/Z _454_/A1 VPWR VPWR VGND VGND gf180mcu_fd_sc_mcu7t5v0__buf_8
Xload_slew32 _414_/B _450_/A2 VPWR VPWR VGND VGND gf180mcu_fd_sc_mcu7t5v0__buf_2
Xload_slew65 _434_/A3 _396_/A2 VPWR VPWR VGND VGND gf180mcu_fd_sc_mcu7t5v0__buf_4
XFILLER_15_594 VPWR VPWR VGND VGND gf180mcu_fd_sc_mcu7t5v0__fillcap_8
Xload_slew76 uio_out[5] _671_/I VPWR VPWR VGND VGND gf180mcu_fd_sc_mcu7t5v0__buf_4
XFILLER_30_597 VPWR VPWR VGND VGND gf180mcu_fd_sc_mcu7t5v0__fillcap_8
XFILLER_21_586 VPWR VPWR VGND VGND gf180mcu_fd_sc_mcu7t5v0__fill_1
XTAP_TAPCELL_ROW_35_386 VPWR VGND gf180mcu_fd_sc_mcu7t5v0__filltie
XFILLER_20_34 VPWR VPWR VGND VGND gf180mcu_fd_sc_mcu7t5v0__fill_1
X_592_ _636_/Q _602_/A2 _593_/A2 VPWR VPWR VGND VGND gf180mcu_fd_sc_mcu7t5v0__nand2_1
XFILLER_8_524 VPWR VPWR VGND VGND gf180mcu_fd_sc_mcu7t5v0__fill_1
XFILLER_12_597 VPWR VPWR VGND VGND gf180mcu_fd_sc_mcu7t5v0__fillcap_8
Xrebuffer109 _498_/A2 _510_/A1 VPWR VPWR VGND VGND gf180mcu_fd_sc_mcu7t5v0__buf_8
XFILLER_22_317 VPWR VPWR VGND VGND gf180mcu_fd_sc_mcu7t5v0__fill_1
XFILLER_30_383 VPWR VPWR VGND VGND gf180mcu_fd_sc_mcu7t5v0__fill_2
XFILLER_34_177 VPWR VPWR VGND VGND gf180mcu_fd_sc_mcu7t5v0__fillcap_64
XFILLER_31_66 VPWR VPWR VGND VGND gf180mcu_fd_sc_mcu7t5v0__fillcap_4
XFILLER_29_450 VPWR VPWR VGND VGND gf180mcu_fd_sc_mcu7t5v0__fill_1
X_644_ _644_/D _646_/CLK _644_/Q VPWR VPWR VGND VGND gf180mcu_fd_sc_mcu7t5v0__dffq_2
X_575_ _575_/A1 _575_/A2 _603_/B _630_/D VPWR VPWR VGND VGND gf180mcu_fd_sc_mcu7t5v0__aoi21_1
XFILLER_16_177 VPWR VPWR VGND VGND gf180mcu_fd_sc_mcu7t5v0__fillcap_64
XFILLER_31_136 VPWR VPWR VGND VGND gf180mcu_fd_sc_mcu7t5v0__fillcap_4
XTAP_TAPCELL_ROW_37_404 VPWR VGND gf180mcu_fd_sc_mcu7t5v0__filltie
XFILLER_11_2 VPWR VPWR VGND VGND gf180mcu_fd_sc_mcu7t5v0__fillcap_64
XFILLER_13_136 VPWR VPWR VGND VGND gf180mcu_fd_sc_mcu7t5v0__fillcap_4
X_360_ _360_/I _437_/B VPWR VPWR VGND VGND gf180mcu_fd_sc_mcu7t5v0__inv_8
XFILLER_5_368 VPWR VPWR VGND VGND gf180mcu_fd_sc_mcu7t5v0__fillcap_8
XFILLER_5_346 VPWR VPWR VGND VGND gf180mcu_fd_sc_mcu7t5v0__fillcap_4
XTAP_TAPCELL_ROW_8_162 VPWR VGND gf180mcu_fd_sc_mcu7t5v0__filltie
X_558_ _642_/Q _585_/B1 _586_/B1 input2/Z _559_/A2 VPWR VPWR VGND VGND gf180mcu_fd_sc_mcu7t5v0__aoi22_1
X_627_ _627_/D _649_/CLK _627_/Q VPWR VPWR VGND VGND gf180mcu_fd_sc_mcu7t5v0__dffq_4
X_489_ _489_/A1 _532_/B _489_/B _493_/A1 VPWR VPWR VGND VGND gf180mcu_fd_sc_mcu7t5v0__aoi21_4
XFILLER_27_206 VPWR VPWR VGND VGND gf180mcu_fd_sc_mcu7t5v0__fillcap_4
XTAP_TAPCELL_ROW_5_132 VPWR VGND gf180mcu_fd_sc_mcu7t5v0__filltie
X_412_ _645_/D _464_/A1 _505_/A2 VPWR VPWR VGND VGND gf180mcu_fd_sc_mcu7t5v0__nand2_2
X_343_ _344_/A1 _351_/A1 _345_/A2 VPWR VPWR VGND VGND gf180mcu_fd_sc_mcu7t5v0__nand2_1
XFILLER_37_559 VPWR VPWR VGND VGND gf180mcu_fd_sc_mcu7t5v0__fill_1
XFILLER_36_592 VPWR VPWR VGND VGND gf180mcu_fd_sc_mcu7t5v0__fill_2
XTAP_TAPCELL_ROW_16_226 VPWR VGND gf180mcu_fd_sc_mcu7t5v0__filltie
X_326_ _654_/Q _655_/Q _325_/Z _616_/A2 VPWR VPWR VGND VGND gf180mcu_fd_sc_mcu7t5v0__nand3_1
XFILLER_10_481 VPWR VPWR VGND VGND gf180mcu_fd_sc_mcu7t5v0__fill_2
XTAP_TAPCELL_ROW_24_292 VPWR VGND gf180mcu_fd_sc_mcu7t5v0__filltie
Xfanout90 _323_/ZN _559_/B VPWR VPWR VGND VGND gf180mcu_fd_sc_mcu7t5v0__buf_4
XTAP_TAPCELL_ROW_0_81 VPWR VGND gf180mcu_fd_sc_mcu7t5v0__filltie
XTAP_TAPCELL_ROW_0_92 VPWR VGND gf180mcu_fd_sc_mcu7t5v0__filltie
XFILLER_18_570 VPWR VPWR VGND VGND gf180mcu_fd_sc_mcu7t5v0__fillcap_16
XFILLER_33_595 VPWR VPWR VGND VGND gf180mcu_fd_sc_mcu7t5v0__fillcap_8
XFILLER_18_34 VPWR VPWR VGND VGND gf180mcu_fd_sc_mcu7t5v0__fill_1
XFILLER_11_212 VPWR VPWR VGND VGND gf180mcu_fd_sc_mcu7t5v0__fillcap_64
XFILLER_38_109 VPWR VPWR VGND VGND gf180mcu_fd_sc_mcu7t5v0__fillcap_8
XFILLER_3_422 VPWR VPWR VGND VGND gf180mcu_fd_sc_mcu7t5v0__fillcap_64
Xload_slew33 _423_/C _414_/B VPWR VPWR VGND VGND gf180mcu_fd_sc_mcu7t5v0__buf_2
XTAP_TAPCELL_ROW_29_340 VPWR VGND gf180mcu_fd_sc_mcu7t5v0__filltie
Xload_slew66 _434_/A2 _396_/A1 VPWR VPWR VGND VGND gf180mcu_fd_sc_mcu7t5v0__buf_4
XFILLER_15_562 VPWR VPWR VGND VGND gf180mcu_fd_sc_mcu7t5v0__fillcap_32
X_309_ _649_/Q _344_/A1 VPWR VPWR VGND VGND gf180mcu_fd_sc_mcu7t5v0__clkinv_1
XFILLER_37_142 VPWR VPWR VGND VGND gf180mcu_fd_sc_mcu7t5v0__fillcap_64
XTAP_TAPCELL_ROW_35_387 VPWR VGND gf180mcu_fd_sc_mcu7t5v0__filltie
XTAP_TAPCELL_ROW_26_310 VPWR VGND gf180mcu_fd_sc_mcu7t5v0__filltie
XFILLER_29_66 VPWR VPWR VGND VGND gf180mcu_fd_sc_mcu7t5v0__fillcap_4
X_591_ _591_/A1 _591_/A2 _601_/B _635_/D VPWR VPWR VGND VGND gf180mcu_fd_sc_mcu7t5v0__aoi21_1
XFILLER_12_521 VPWR VPWR VGND VGND gf180mcu_fd_sc_mcu7t5v0__fillcap_4
XFILLER_6_37 VPWR VPWR VGND VGND gf180mcu_fd_sc_mcu7t5v0__fillcap_64
XFILLER_19_142 VPWR VPWR VGND VGND gf180mcu_fd_sc_mcu7t5v0__fillcap_64
XFILLER_34_101 VPWR VPWR VGND VGND gf180mcu_fd_sc_mcu7t5v0__fillcap_4
XFILLER_38_473 VPWR VPWR VGND VGND gf180mcu_fd_sc_mcu7t5v0__fill_2
X_574_ _646_/Q _585_/B1 _586_/B1 input6/Z _575_/A2 VPWR VPWR VGND VGND gf180mcu_fd_sc_mcu7t5v0__aoi22_1
X_643_ _643_/D _657_/CLK _643_/Q VPWR VPWR VGND VGND gf180mcu_fd_sc_mcu7t5v0__dffq_2
XFILLER_16_101 VPWR VPWR VGND VGND gf180mcu_fd_sc_mcu7t5v0__fillcap_4
XFILLER_17_602 VPWR VPWR VGND VGND gf180mcu_fd_sc_mcu7t5v0__fill_2
XFILLER_8_333 VPWR VPWR VGND VGND gf180mcu_fd_sc_mcu7t5v0__fillcap_4
XFILLER_8_311 VPWR VPWR VGND VGND gf180mcu_fd_sc_mcu7t5v0__fillcap_4
XTAP_TAPCELL_ROW_37_405 VPWR VGND gf180mcu_fd_sc_mcu7t5v0__filltie
XFILLER_26_34 VPWR VPWR VGND VGND gf180mcu_fd_sc_mcu7t5v0__fill_1
XFILLER_26_454 VPWR VPWR VGND VGND gf180mcu_fd_sc_mcu7t5v0__fill_1
XFILLER_36_229 VPWR VPWR VGND VGND gf180mcu_fd_sc_mcu7t5v0__fill_2
X_626_ _626_/D _633_/CLK _626_/Q VPWR VPWR VGND VGND gf180mcu_fd_sc_mcu7t5v0__dffq_4
X_488_ _506_/B _511_/A1 _488_/B _488_/C _489_/B VPWR VPWR VGND VGND gf180mcu_fd_sc_mcu7t5v0__oai211_4
X_557_ _618_/Q _585_/A2 _586_/A2 _634_/Q _559_/A1 VPWR VPWR VGND VGND gf180mcu_fd_sc_mcu7t5v0__aoi22_1
XFILLER_10_107 VPWR VPWR VGND VGND gf180mcu_fd_sc_mcu7t5v0__fillcap_64
XFILLER_23_457 VPWR VPWR VGND VGND gf180mcu_fd_sc_mcu7t5v0__fill_1
XFILLER_35_284 VPWR VPWR VGND VGND gf180mcu_fd_sc_mcu7t5v0__fill_1
XFILLER_2_317 VPWR VPWR VGND VGND gf180mcu_fd_sc_mcu7t5v0__fillcap_64
XFILLER_37_66 VPWR VPWR VGND VGND gf180mcu_fd_sc_mcu7t5v0__fillcap_4
XTAP_TAPCELL_ROW_5_133 VPWR VGND gf180mcu_fd_sc_mcu7t5v0__filltie
X_342_ _648_/Q _647_/Q _342_/A3 _351_/A1 VPWR VPWR VGND VGND gf180mcu_fd_sc_mcu7t5v0__nand3_2
X_411_ _411_/A1 _474_/A2 _478_/A1 VPWR VPWR VGND VGND gf180mcu_fd_sc_mcu7t5v0__nor2_4
X_609_ _609_/A1 _609_/A2 _652_/D VPWR VPWR VGND VGND gf180mcu_fd_sc_mcu7t5v0__nor2_1
XTAP_TAPCELL_ROW_2_103 VPWR VGND gf180mcu_fd_sc_mcu7t5v0__filltie
XFILLER_23_276 VPWR VPWR VGND VGND gf180mcu_fd_sc_mcu7t5v0__fillcap_4
XFILLER_3_604 VPWR VPWR VGND VGND gf180mcu_fd_sc_mcu7t5v0__fill_1
XTAP_TAPCELL_ROW_16_227 VPWR VGND gf180mcu_fd_sc_mcu7t5v0__filltie
X_325_ _650_/Q _651_/Q _652_/Q _653_/Q _325_/Z VPWR VPWR VGND VGND gf180mcu_fd_sc_mcu7t5v0__and4_4
XTAP_TAPCELL_ROW_24_293 VPWR VGND gf180mcu_fd_sc_mcu7t5v0__filltie
Xfanout91 _323_/ZN _601_/B VPWR VPWR VGND VGND gf180mcu_fd_sc_mcu7t5v0__buf_1
XFILLER_6_453 VPWR VPWR VGND VGND gf180mcu_fd_sc_mcu7t5v0__fill_2
XTAP_TAPCELL_ROW_0_82 VPWR VGND gf180mcu_fd_sc_mcu7t5v0__filltie
XTAP_TAPCELL_ROW_0_93 VPWR VGND gf180mcu_fd_sc_mcu7t5v0__filltie
XFILLER_34_34 VPWR VPWR VGND VGND gf180mcu_fd_sc_mcu7t5v0__fill_1
XFILLER_7_206 VPWR VPWR VGND VGND gf180mcu_fd_sc_mcu7t5v0__fillcap_4
XFILLER_1_2 VPWR VPWR VGND VGND gf180mcu_fd_sc_mcu7t5v0__fillcap_64
XPHY_EDGE_ROW_28_Left_67 VPWR VGND gf180mcu_fd_sc_mcu7t5v0__endcap
Xload_slew78 uio_out[4] _670_/I VPWR VPWR VGND VGND gf180mcu_fd_sc_mcu7t5v0__buf_4
XFILLER_34_2 VPWR VPWR VGND VGND gf180mcu_fd_sc_mcu7t5v0__fillcap_32
XTAP_TAPCELL_ROW_35_388 VPWR VGND gf180mcu_fd_sc_mcu7t5v0__filltie
X_590_ _635_/Q _602_/A2 _591_/A2 VPWR VPWR VGND VGND gf180mcu_fd_sc_mcu7t5v0__nand2_1
XTAP_TAPCELL_ROW_26_311 VPWR VGND gf180mcu_fd_sc_mcu7t5v0__filltie
XTAP_TAPCELL_ROW_32_358 VPWR VGND gf180mcu_fd_sc_mcu7t5v0__filltie
XFILLER_21_352 VPWR VPWR VGND VGND gf180mcu_fd_sc_mcu7t5v0__fillcap_4
X_642_ _642_/D _657_/CLK _642_/Q VPWR VPWR VGND VGND gf180mcu_fd_sc_mcu7t5v0__dffq_2
X_573_ _622_/Q _585_/A2 _586_/A2 _638_/Q _575_/A1 VPWR VPWR VGND VGND gf180mcu_fd_sc_mcu7t5v0__aoi22_1
XPHY_EDGE_ROW_19_Right_19 VPWR VGND gf180mcu_fd_sc_mcu7t5v0__endcap
XFILLER_12_341 VPWR VPWR VGND VGND gf180mcu_fd_sc_mcu7t5v0__fill_1
Xclkbuf_3_1__f_clk clkbuf_0_clk/Z _638_/CLK VPWR VPWR VGND VGND gf180mcu_fd_sc_mcu7t5v0__clkbuf_8
XPHY_EDGE_ROW_28_Right_28 VPWR VGND gf180mcu_fd_sc_mcu7t5v0__endcap
XPHY_EDGE_ROW_37_Right_37 VPWR VGND gf180mcu_fd_sc_mcu7t5v0__endcap
XTAP_TAPCELL_ROW_37_406 VPWR VGND gf180mcu_fd_sc_mcu7t5v0__filltie
XFILLER_30_171 VPWR VPWR VGND VGND gf180mcu_fd_sc_mcu7t5v0__fillcap_4
XPHY_EDGE_ROW_15_Left_54 VPWR VGND gf180mcu_fd_sc_mcu7t5v0__endcap
XFILLER_29_260 VPWR VPWR VGND VGND gf180mcu_fd_sc_mcu7t5v0__fillcap_4
XFILLER_29_282 VPWR VPWR VGND VGND gf180mcu_fd_sc_mcu7t5v0__fill_1
X_625_ _625_/D _638_/CLK _625_/Q VPWR VPWR VGND VGND gf180mcu_fd_sc_mcu7t5v0__dffq_1
XFILLER_12_171 VPWR VPWR VGND VGND gf180mcu_fd_sc_mcu7t5v0__fillcap_4
X_487_ _645_/D wire25/Z _488_/B VPWR VPWR VGND VGND gf180mcu_fd_sc_mcu7t5v0__nand2_4
X_556_ input2/Z _586_/B1 _589_/A1 VPWR VPWR VGND VGND gf180mcu_fd_sc_mcu7t5v0__nand2_1
XFILLER_4_381 VPWR VPWR VGND VGND gf180mcu_fd_sc_mcu7t5v0__fillcap_4
XFILLER_12_37 VPWR VPWR VGND VGND gf180mcu_fd_sc_mcu7t5v0__fillcap_64
XPHY_EDGE_ROW_0_Left_39 VPWR VGND gf180mcu_fd_sc_mcu7t5v0__endcap
XTAP_TAPCELL_ROW_5_134 VPWR VGND gf180mcu_fd_sc_mcu7t5v0__filltie
X_410_ _410_/A1 _410_/A2 _410_/B _515_/B _417_/C VPWR VPWR VGND VGND gf180mcu_fd_sc_mcu7t5v0__oai211_1
XFILLER_26_241 VPWR VPWR VGND VGND gf180mcu_fd_sc_mcu7t5v0__fillcap_4
XFILLER_26_263 VPWR VPWR VGND VGND gf180mcu_fd_sc_mcu7t5v0__fillcap_8
X_341_ _647_/Q _342_/A3 _348_/A1 VPWR VPWR VGND VGND gf180mcu_fd_sc_mcu7t5v0__nand2_2
X_608_ _613_/B _610_/A2 _609_/A2 VPWR VPWR VGND VGND gf180mcu_fd_sc_mcu7t5v0__nand2_1
X_539_ _536_/Z _539_/A2 _543_/B _543_/A2 _542_/A2 VPWR VPWR VGND VGND gf180mcu_fd_sc_mcu7t5v0__aoi22_2
XFILLER_32_255 VPWR VPWR VGND VGND gf180mcu_fd_sc_mcu7t5v0__fill_2
XTAP_TAPCELL_ROW_2_104 VPWR VGND gf180mcu_fd_sc_mcu7t5v0__filltie
XFILLER_36_594 VPWR VPWR VGND VGND gf180mcu_fd_sc_mcu7t5v0__fill_1
XTAP_TAPCELL_ROW_16_228 VPWR VGND gf180mcu_fd_sc_mcu7t5v0__filltie
XFILLER_6_410 VPWR VPWR VGND VGND gf180mcu_fd_sc_mcu7t5v0__fill_2
X_324_ _651_/Q _650_/Q _652_/Q _610_/A2 VPWR VPWR VGND VGND gf180mcu_fd_sc_mcu7t5v0__nand3_1
XTAP_TAPCELL_ROW_24_294 VPWR VGND gf180mcu_fd_sc_mcu7t5v0__filltie
Xfanout92 _323_/ZN _603_/B VPWR VPWR VGND VGND gf180mcu_fd_sc_mcu7t5v0__buf_2
XFILLER_10_483 VPWR VPWR VGND VGND gf180mcu_fd_sc_mcu7t5v0__fill_1
XFILLER_37_347 VPWR VPWR VGND VGND gf180mcu_fd_sc_mcu7t5v0__fill_2
XTAP_TAPCELL_ROW_0_83 VPWR VGND gf180mcu_fd_sc_mcu7t5v0__filltie
XTAP_TAPCELL_ROW_0_94 VPWR VGND gf180mcu_fd_sc_mcu7t5v0__filltie
XFILLER_18_594 VPWR VPWR VGND VGND gf180mcu_fd_sc_mcu7t5v0__fill_1
XFILLER_20_247 VPWR VPWR VGND VGND gf180mcu_fd_sc_mcu7t5v0__fillcap_16
XFILLER_28_358 VPWR VPWR VGND VGND gf180mcu_fd_sc_mcu7t5v0__fill_1
XFILLER_24_597 VPWR VPWR VGND VGND gf180mcu_fd_sc_mcu7t5v0__fillcap_8
XPHY_EDGE_ROW_3_Left_42 VPWR VGND gf180mcu_fd_sc_mcu7t5v0__endcap
Xload_slew24 _349_/I _475_/B VPWR VPWR VGND VGND gf180mcu_fd_sc_mcu7t5v0__buf_4
Xload_slew57 wire55/I _446_/B VPWR VPWR VGND VGND gf180mcu_fd_sc_mcu7t5v0__clkbuf_1
XFILLER_15_553 VPWR VPWR VGND VGND gf180mcu_fd_sc_mcu7t5v0__fillcap_4
XFILLER_34_317 VPWR VPWR VGND VGND gf180mcu_fd_sc_mcu7t5v0__fill_2
Xload_slew35 _390_/ZN wire34/I VPWR VPWR VGND VGND gf180mcu_fd_sc_mcu7t5v0__buf_4
XFILLER_30_556 VPWR VPWR VGND VGND gf180mcu_fd_sc_mcu7t5v0__fillcap_4
XFILLER_27_2 VPWR VPWR VGND VGND gf180mcu_fd_sc_mcu7t5v0__fillcap_64
XFILLER_1_72 VPWR VPWR VGND VGND gf180mcu_fd_sc_mcu7t5v0__fillcap_64
XTAP_TAPCELL_ROW_35_389 VPWR VGND gf180mcu_fd_sc_mcu7t5v0__filltie
XFILLER_20_37 VPWR VPWR VGND VGND gf180mcu_fd_sc_mcu7t5v0__fillcap_64
XTAP_TAPCELL_ROW_26_312 VPWR VGND gf180mcu_fd_sc_mcu7t5v0__filltie
XFILLER_28_177 VPWR VPWR VGND VGND gf180mcu_fd_sc_mcu7t5v0__fillcap_64
XFILLER_8_527 VPWR VPWR VGND VGND gf180mcu_fd_sc_mcu7t5v0__fillcap_64
XFILLER_12_589 VPWR VPWR VGND VGND gf180mcu_fd_sc_mcu7t5v0__fillcap_4
XFILLER_3_276 VPWR VPWR VGND VGND gf180mcu_fd_sc_mcu7t5v0__fillcap_4
XTAP_TAPCELL_ROW_32_359 VPWR VGND gf180mcu_fd_sc_mcu7t5v0__filltie
XFILLER_38_475 VPWR VPWR VGND VGND gf180mcu_fd_sc_mcu7t5v0__fill_1
XFILLER_25_136 VPWR VPWR VGND VGND gf180mcu_fd_sc_mcu7t5v0__fillcap_4
X_572_ input6/Z _586_/B1 _597_/A1 VPWR VPWR VGND VGND gf180mcu_fd_sc_mcu7t5v0__nand2_1
X_641_ _641_/D _646_/CLK _641_/Q VPWR VPWR VGND VGND gf180mcu_fd_sc_mcu7t5v0__dffq_1
XFILLER_17_604 VPWR VPWR VGND VGND gf180mcu_fd_sc_mcu7t5v0__fill_1
XTAP_TAPCELL_ROW_37_407 VPWR VGND gf180mcu_fd_sc_mcu7t5v0__filltie
XTAP_TAPCELL_ROW_8_154 VPWR VGND gf180mcu_fd_sc_mcu7t5v0__filltie
X_555_ _555_/A1 _555_/A2 _602_/A2 VPWR VPWR VGND VGND gf180mcu_fd_sc_mcu7t5v0__nand2_2
XFILLER_36_209 VPWR VPWR VGND VGND gf180mcu_fd_sc_mcu7t5v0__fillcap_16
X_624_ _624_/D _638_/CLK _624_/Q VPWR VPWR VGND VGND gf180mcu_fd_sc_mcu7t5v0__dffq_1
X_486_ _513_/B2 _486_/A2 _485_/Z _483_/B _620_/D VPWR VPWR VGND VGND gf180mcu_fd_sc_mcu7t5v0__aoi22_1
XPHY_EDGE_ROW_32_Left_71 VPWR VGND gf180mcu_fd_sc_mcu7t5v0__endcap
XFILLER_31_492 VPWR VPWR VGND VGND gf180mcu_fd_sc_mcu7t5v0__fill_1
XTAP_TAPCELL_ROW_5_135 VPWR VGND gf180mcu_fd_sc_mcu7t5v0__filltie
XFILLER_22_470 VPWR VPWR VGND VGND gf180mcu_fd_sc_mcu7t5v0__fill_2
X_340_ _646_/Q _645_/Q _384_/A1 _384_/A2 _356_/A3 VPWR VPWR VGND VGND gf180mcu_fd_sc_mcu7t5v0__nand4_4
XFILLER_1_352 VPWR VPWR VGND VGND gf180mcu_fd_sc_mcu7t5v0__fillcap_64
XTAP_TAPCELL_ROW_19_248 VPWR VGND gf180mcu_fd_sc_mcu7t5v0__filltie
X_607_ _651_/Q _650_/Q _652_/Q _609_/A1 VPWR VPWR VGND VGND gf180mcu_fd_sc_mcu7t5v0__aoi21_1
X_538_ _532_/C _538_/A2 _543_/A2 VPWR VPWR VGND VGND gf180mcu_fd_sc_mcu7t5v0__nand2_1
XFILLER_9_485 VPWR VPWR VGND VGND gf180mcu_fd_sc_mcu7t5v0__fillcap_4
XFILLER_13_492 VPWR VPWR VGND VGND gf180mcu_fd_sc_mcu7t5v0__fillcap_4
X_469_ _469_/A1 _469_/A2 _541_/B _470_/A3 VPWR VPWR VGND VGND gf180mcu_fd_sc_mcu7t5v0__aoi21_1
XTAP_TAPCELL_ROW_2_105 VPWR VGND gf180mcu_fd_sc_mcu7t5v0__filltie
XFILLER_11_418 VPWR VPWR VGND VGND gf180mcu_fd_sc_mcu7t5v0__fill_2
XFILLER_23_212 VPWR VPWR VGND VGND gf180mcu_fd_sc_mcu7t5v0__fillcap_64
XFILLER_19_518 VPWR VPWR VGND VGND gf180mcu_fd_sc_mcu7t5v0__fillcap_4
XTAP_TAPCELL_ROW_16_229 VPWR VGND gf180mcu_fd_sc_mcu7t5v0__filltie
X_323_ _323_/I _323_/ZN VPWR VPWR VGND VGND gf180mcu_fd_sc_mcu7t5v0__clkinv_1
XTAP_TAPCELL_ROW_24_295 VPWR VGND gf180mcu_fd_sc_mcu7t5v0__filltie
Xfanout60 _356_/ZN _488_/C VPWR VPWR VGND VGND gf180mcu_fd_sc_mcu7t5v0__buf_8
Xfanout71 _370_/A2 _383_/A1 VPWR VPWR VGND VGND gf180mcu_fd_sc_mcu7t5v0__buf_8
Xfanout93 input1/Z _323_/I VPWR VPWR VGND VGND gf180mcu_fd_sc_mcu7t5v0__buf_4
XTAP_TAPCELL_ROW_0_84 VPWR VGND gf180mcu_fd_sc_mcu7t5v0__filltie
XFILLER_9_282 VPWR VPWR VGND VGND gf180mcu_fd_sc_mcu7t5v0__fillcap_32
XFILLER_18_37 VPWR VPWR VGND VGND gf180mcu_fd_sc_mcu7t5v0__fillcap_64
XTAP_TAPCELL_ROW_21_265 VPWR VGND gf180mcu_fd_sc_mcu7t5v0__filltie
Xload_slew47 _422_/C _439_/A1 VPWR VPWR VGND VGND gf180mcu_fd_sc_mcu7t5v0__buf_3
Xload_slew69 wire70/Z _384_/A1 VPWR VPWR VGND VGND gf180mcu_fd_sc_mcu7t5v0__buf_8
Xload_slew58 _422_/B wire55/I VPWR VPWR VGND VGND gf180mcu_fd_sc_mcu7t5v0__buf_8
XFILLER_27_370 VPWR VPWR VGND VGND gf180mcu_fd_sc_mcu7t5v0__fill_1
XFILLER_6_241 VPWR VPWR VGND VGND gf180mcu_fd_sc_mcu7t5v0__fillcap_4
XFILLER_38_602 VPWR VPWR VGND VGND gf180mcu_fd_sc_mcu7t5v0__fill_2
XFILLER_28_101 VPWR VPWR VGND VGND gf180mcu_fd_sc_mcu7t5v0__fillcap_4
XFILLER_12_513 VPWR VPWR VGND VGND gf180mcu_fd_sc_mcu7t5v0__fillcap_8
XTAP_TAPCELL_ROW_26_313 VPWR VGND gf180mcu_fd_sc_mcu7t5v0__filltie
XFILLER_7_594 VPWR VPWR VGND VGND gf180mcu_fd_sc_mcu7t5v0__fillcap_8
XPHY_EDGE_ROW_1_Right_1 VPWR VGND gf180mcu_fd_sc_mcu7t5v0__endcap
X_640_ _640_/D _646_/CLK _640_/Q VPWR VPWR VGND VGND gf180mcu_fd_sc_mcu7t5v0__dffq_1
X_571_ _571_/A1 _571_/A2 _603_/B _629_/D VPWR VPWR VGND VGND gf180mcu_fd_sc_mcu7t5v0__aoi21_1
XFILLER_12_310 VPWR VPWR VGND VGND gf180mcu_fd_sc_mcu7t5v0__fillcap_4
XFILLER_4_597 VPWR VPWR VGND VGND gf180mcu_fd_sc_mcu7t5v0__fillcap_8
XTAP_TAPCELL_ROW_37_408 VPWR VGND gf180mcu_fd_sc_mcu7t5v0__filltie
XFILLER_22_107 VPWR VPWR VGND VGND gf180mcu_fd_sc_mcu7t5v0__fillcap_64
XFILLER_7_72 VPWR VPWR VGND VGND gf180mcu_fd_sc_mcu7t5v0__fillcap_64
XFILLER_38_240 VPWR VPWR VGND VGND gf180mcu_fd_sc_mcu7t5v0__fill_1
XFILLER_26_37 VPWR VPWR VGND VGND gf180mcu_fd_sc_mcu7t5v0__fillcap_64
XTAP_TAPCELL_ROW_8_155 VPWR VGND gf180mcu_fd_sc_mcu7t5v0__filltie
XFILLER_1_556 VPWR VPWR VGND VGND gf180mcu_fd_sc_mcu7t5v0__fillcap_4
X_554_ _321_/I _322_/I _554_/ZN VPWR VPWR VGND VGND gf180mcu_fd_sc_mcu7t5v0__nor2_1
X_485_ _649_/D _485_/A2 _485_/Z VPWR VPWR VGND VGND gf180mcu_fd_sc_mcu7t5v0__and2_1
X_623_ _623_/D _645_/CLK _623_/Q VPWR VPWR VGND VGND gf180mcu_fd_sc_mcu7t5v0__dffq_1
XFILLER_8_177 VPWR VPWR VGND VGND gf180mcu_fd_sc_mcu7t5v0__fillcap_64
XTAP_TAPCELL_ROW_5_136 VPWR VGND gf180mcu_fd_sc_mcu7t5v0__filltie
XFILLER_5_136 VPWR VPWR VGND VGND gf180mcu_fd_sc_mcu7t5v0__fillcap_4
XFILLER_17_276 VPWR VPWR VGND VGND gf180mcu_fd_sc_mcu7t5v0__fillcap_4
X_606_ _651_/Q _650_/Q _606_/B _651_/D VPWR VPWR VGND VGND gf180mcu_fd_sc_mcu7t5v0__aoi21_1
XTAP_TAPCELL_ROW_19_249 VPWR VGND gf180mcu_fd_sc_mcu7t5v0__filltie
X_468_ _437_/B _468_/A2 _505_/A2 _496_/A2 _468_/C _469_/A2 VPWR VPWR VGND VGND gf180mcu_fd_sc_mcu7t5v0__oai221_2
X_537_ _520_/B _537_/A2 _543_/B VPWR VPWR VGND VGND gf180mcu_fd_sc_mcu7t5v0__nor2_4
XTAP_TAPCELL_ROW_10_171 VPWR VGND gf180mcu_fd_sc_mcu7t5v0__filltie
X_399_ _404_/A2 _404_/A4 _399_/B _559_/B _516_/B VPWR VPWR VGND VGND gf180mcu_fd_sc_mcu7t5v0__aoi211_4
XTAP_TAPCELL_ROW_2_106 VPWR VGND gf180mcu_fd_sc_mcu7t5v0__filltie
X_322_ _322_/I _555_/A2 VPWR VPWR VGND VGND gf180mcu_fd_sc_mcu7t5v0__clkinv_1
XFILLER_10_452 VPWR VPWR VGND VGND gf180mcu_fd_sc_mcu7t5v0__fill_2
Xfanout61 _356_/ZN _471_/B VPWR VPWR VGND VGND gf180mcu_fd_sc_mcu7t5v0__buf_3
Xfanout50 fanout50/I _422_/B VPWR VPWR VGND VGND gf180mcu_fd_sc_mcu7t5v0__buf_8
XTAP_TAPCELL_ROW_24_296 VPWR VGND gf180mcu_fd_sc_mcu7t5v0__filltie
Xfanout94 input1/Z _613_/B VPWR VPWR VGND VGND gf180mcu_fd_sc_mcu7t5v0__buf_2
XTAP_TAPCELL_ROW_0_85 VPWR VGND gf180mcu_fd_sc_mcu7t5v0__filltie
XFILLER_37_349 VPWR VPWR VGND VGND gf180mcu_fd_sc_mcu7t5v0__fill_1
Xclkbuf_3_7__f_clk clkbuf_0_clk/Z _656_/CLK VPWR VPWR VGND VGND gf180mcu_fd_sc_mcu7t5v0__clkbuf_8
XFILLER_34_37 VPWR VPWR VGND VGND gf180mcu_fd_sc_mcu7t5v0__fillcap_64
XTAP_TAPCELL_ROW_21_266 VPWR VGND gf180mcu_fd_sc_mcu7t5v0__filltie
Xload_slew26 _474_/A1 _411_/A1 VPWR VPWR VGND VGND gf180mcu_fd_sc_mcu7t5v0__buf_4
XTAP_TAPCELL_ROW_29_333 VPWR VGND gf180mcu_fd_sc_mcu7t5v0__filltie
XFILLER_34_319 VPWR VPWR VGND VGND gf180mcu_fd_sc_mcu7t5v0__fill_1
XFILLER_33_352 VPWR VPWR VGND VGND gf180mcu_fd_sc_mcu7t5v0__fill_1
XFILLER_8_518 VPWR VPWR VGND VGND gf180mcu_fd_sc_mcu7t5v0__fillcap_4
XTAP_TAPCELL_ROW_26_314 VPWR VGND gf180mcu_fd_sc_mcu7t5v0__filltie
XTAP_TAPCELL_ROW_34_380 VPWR VGND gf180mcu_fd_sc_mcu7t5v0__filltie
XFILLER_3_212 VPWR VPWR VGND VGND gf180mcu_fd_sc_mcu7t5v0__fillcap_64
XFILLER_20_591 VPWR VPWR VGND VGND gf180mcu_fd_sc_mcu7t5v0__fillcap_4
XFILLER_15_330 VPWR VPWR VGND VGND gf180mcu_fd_sc_mcu7t5v0__fill_1
XFILLER_7_562 VPWR VPWR VGND VGND gf180mcu_fd_sc_mcu7t5v0__fillcap_32
XFILLER_32_2 VPWR VPWR VGND VGND gf180mcu_fd_sc_mcu7t5v0__fillcap_32
XFILLER_38_444 VPWR VPWR VGND VGND gf180mcu_fd_sc_mcu7t5v0__fill_2
XTAP_TAPCELL_ROW_31_350 VPWR VGND gf180mcu_fd_sc_mcu7t5v0__filltie
X_570_ _645_/Q _585_/B1 _586_/B1 input5/Z _571_/A2 VPWR VPWR VGND VGND gf180mcu_fd_sc_mcu7t5v0__aoi22_1
XFILLER_24_171 VPWR VPWR VGND VGND gf180mcu_fd_sc_mcu7t5v0__fillcap_4
XFILLER_4_521 VPWR VPWR VGND VGND gf180mcu_fd_sc_mcu7t5v0__fillcap_4
Xclkbuf_0_clk clk clkbuf_0_clk/Z VPWR VPWR VGND VGND gf180mcu_fd_sc_mcu7t5v0__clkbuf_8
XPHY_EDGE_ROW_15_Right_15 VPWR VGND gf180mcu_fd_sc_mcu7t5v0__endcap
XFILLER_38_274 VPWR VPWR VGND VGND gf180mcu_fd_sc_mcu7t5v0__fill_1
XPHY_EDGE_ROW_24_Right_24 VPWR VGND gf180mcu_fd_sc_mcu7t5v0__endcap
XPHY_EDGE_ROW_33_Right_33 VPWR VGND gf180mcu_fd_sc_mcu7t5v0__endcap
XTAP_TAPCELL_ROW_8_156 VPWR VGND gf180mcu_fd_sc_mcu7t5v0__filltie
X_622_ _622_/D _649_/CLK _622_/Q VPWR VPWR VGND VGND gf180mcu_fd_sc_mcu7t5v0__dffq_1
X_553_ _555_/A1 _555_/A2 _586_/A2 VPWR VPWR VGND VGND gf180mcu_fd_sc_mcu7t5v0__nor2_4
XFILLER_9_602 VPWR VPWR VGND VGND gf180mcu_fd_sc_mcu7t5v0__fill_2
X_484_ _484_/A1 _455_/Z _482_/B _484_/B _485_/A2 VPWR VPWR VGND VGND gf180mcu_fd_sc_mcu7t5v0__oai31_1
XFILLER_8_101 VPWR VPWR VGND VGND gf180mcu_fd_sc_mcu7t5v0__fillcap_4
XPHY_EDGE_ROW_19_Left_58 VPWR VGND gf180mcu_fd_sc_mcu7t5v0__endcap
XFILLER_22_472 VPWR VPWR VGND VGND gf180mcu_fd_sc_mcu7t5v0__fill_1
X_605_ _651_/Q _650_/Q _613_/B _606_/B VPWR VPWR VGND VGND gf180mcu_fd_sc_mcu7t5v0__oai21_1
X_398_ _454_/A2 _402_/B _646_/D _406_/A2 VPWR VPWR VGND VGND gf180mcu_fd_sc_mcu7t5v0__oai21_1
X_467_ _470_/A2 _467_/A2 _649_/D _470_/B VPWR VPWR VGND VGND gf180mcu_fd_sc_mcu7t5v0__oai21_2
X_536_ _536_/A1 _536_/A2 _536_/Z VPWR VPWR VGND VGND gf180mcu_fd_sc_mcu7t5v0__or2_2
XFILLER_32_247 VPWR VPWR VGND VGND gf180mcu_fd_sc_mcu7t5v0__fillcap_8
XTAP_TAPCELL_ROW_10_172 VPWR VGND gf180mcu_fd_sc_mcu7t5v0__filltie
XTAP_TAPCELL_ROW_2_107 VPWR VGND gf180mcu_fd_sc_mcu7t5v0__filltie
XFILLER_36_597 VPWR VPWR VGND VGND gf180mcu_fd_sc_mcu7t5v0__fillcap_8
XFILLER_2_107 VPWR VPWR VGND VGND gf180mcu_fd_sc_mcu7t5v0__fillcap_64
XFILLER_14_247 VPWR VPWR VGND VGND gf180mcu_fd_sc_mcu7t5v0__fillcap_16
X_321_ _321_/I _555_/A1 VPWR VPWR VGND VGND gf180mcu_fd_sc_mcu7t5v0__clkinv_1
XFILLER_6_457 VPWR VPWR VGND VGND gf180mcu_fd_sc_mcu7t5v0__fillcap_64
XFILLER_13_72 VPWR VPWR VGND VGND gf180mcu_fd_sc_mcu7t5v0__fillcap_64
XTAP_TAPCELL_ROW_24_297 VPWR VGND gf180mcu_fd_sc_mcu7t5v0__filltie
XTAP_TAPCELL_ROW_0_86 VPWR VGND gf180mcu_fd_sc_mcu7t5v0__filltie
XFILLER_38_91 VPWR VPWR VGND VGND gf180mcu_fd_sc_mcu7t5v0__fill_1
XFILLER_18_586 VPWR VPWR VGND VGND gf180mcu_fd_sc_mcu7t5v0__fillcap_8
XFILLER_18_597 VPWR VPWR VGND VGND gf180mcu_fd_sc_mcu7t5v0__fillcap_8
XTAP_TAPCELL_ROW_15_220 VPWR VGND gf180mcu_fd_sc_mcu7t5v0__filltie
X_519_ _532_/C _488_/B _495_/B _520_/A2 VPWR VPWR VGND VGND gf180mcu_fd_sc_mcu7t5v0__nand3_1
XFILLER_11_206 VPWR VPWR VGND VGND gf180mcu_fd_sc_mcu7t5v0__fillcap_4
XFILLER_3_416 VPWR VPWR VGND VGND gf180mcu_fd_sc_mcu7t5v0__fillcap_4
XTAP_TAPCELL_ROW_21_267 VPWR VGND gf180mcu_fd_sc_mcu7t5v0__filltie
XFILLER_19_306 VPWR VPWR VGND VGND gf180mcu_fd_sc_mcu7t5v0__fill_2
XTAP_TAPCELL_ROW_29_334 VPWR VGND gf180mcu_fd_sc_mcu7t5v0__filltie
Xload_slew16 _345_/ZN _513_/B2 VPWR VPWR VGND VGND gf180mcu_fd_sc_mcu7t5v0__buf_2
XFILLER_38_604 VPWR VPWR VGND VGND gf180mcu_fd_sc_mcu7t5v0__fill_1
XFILLER_37_136 VPWR VPWR VGND VGND gf180mcu_fd_sc_mcu7t5v0__fillcap_4
XFILLER_21_559 VPWR VPWR VGND VGND gf180mcu_fd_sc_mcu7t5v0__fill_1
XTAP_TAPCELL_ROW_26_315 VPWR VGND gf180mcu_fd_sc_mcu7t5v0__filltie
XPHY_EDGE_ROW_7_Left_46 VPWR VGND gf180mcu_fd_sc_mcu7t5v0__endcap
XTAP_TAPCELL_ROW_34_381 VPWR VGND gf180mcu_fd_sc_mcu7t5v0__filltie
XFILLER_19_136 VPWR VPWR VGND VGND gf180mcu_fd_sc_mcu7t5v0__fillcap_4
XFILLER_25_2 VPWR VPWR VGND VGND gf180mcu_fd_sc_mcu7t5v0__fillcap_64
XTAP_TAPCELL_ROW_31_351 VPWR VGND gf180mcu_fd_sc_mcu7t5v0__filltie
XFILLER_21_72 VPWR VPWR VGND VGND gf180mcu_fd_sc_mcu7t5v0__fillcap_64
XFILLER_21_142 VPWR VPWR VGND VGND gf180mcu_fd_sc_mcu7t5v0__fillcap_64
XTAP_TAPCELL_ROW_8_157 VPWR VGND gf180mcu_fd_sc_mcu7t5v0__filltie
X_621_ _621_/D _633_/CLK _621_/Q VPWR VPWR VGND VGND gf180mcu_fd_sc_mcu7t5v0__dffq_1
X_552_ _321_/I _555_/A2 _585_/B1 VPWR VPWR VGND VGND gf180mcu_fd_sc_mcu7t5v0__nor2_4
XFILLER_25_492 VPWR VPWR VGND VGND gf180mcu_fd_sc_mcu7t5v0__fill_2
X_483_ _541_/B _483_/A2 _483_/B _486_/A2 VPWR VPWR VGND VGND gf180mcu_fd_sc_mcu7t5v0__oai21_1
XFILLER_0_580 VPWR VPWR VGND VGND gf180mcu_fd_sc_mcu7t5v0__fillcap_16
XFILLER_23_418 VPWR VPWR VGND VGND gf180mcu_fd_sc_mcu7t5v0__fill_2
XFILLER_35_212 VPWR VPWR VGND VGND gf180mcu_fd_sc_mcu7t5v0__fillcap_16
XPHY_EDGE_ROW_36_Left_75 VPWR VGND gf180mcu_fd_sc_mcu7t5v0__endcap
X_604_ _650_/Q _559_/B _650_/D VPWR VPWR VGND VGND gf180mcu_fd_sc_mcu7t5v0__nor2_1
XFILLER_17_212 VPWR VPWR VGND VGND gf180mcu_fd_sc_mcu7t5v0__fillcap_64
XPHY_EDGE_ROW_20_Left_59 VPWR VGND gf180mcu_fd_sc_mcu7t5v0__endcap
X_535_ _648_/D _535_/A2 _539_/A2 VPWR VPWR VGND VGND gf180mcu_fd_sc_mcu7t5v0__nand2_1
XFILLER_9_477 VPWR VPWR VGND VGND gf180mcu_fd_sc_mcu7t5v0__fillcap_8
XFILLER_9_422 VPWR VPWR VGND VGND gf180mcu_fd_sc_mcu7t5v0__fillcap_4
X_397_ _414_/C _450_/A2 _402_/B VPWR VPWR VGND VGND gf180mcu_fd_sc_mcu7t5v0__or2_1
X_466_ _466_/A1 _469_/A1 _541_/B _467_/A2 VPWR VPWR VGND VGND gf180mcu_fd_sc_mcu7t5v0__aoi21_1
XTAP_TAPCELL_ROW_10_173 VPWR VGND gf180mcu_fd_sc_mcu7t5v0__filltie
XFILLER_4_171 VPWR VPWR VGND VGND gf180mcu_fd_sc_mcu7t5v0__fillcap_4
XTAP_TAPCELL_ROW_2_108 VPWR VGND gf180mcu_fd_sc_mcu7t5v0__filltie
XTAP_TAPCELL_ROW_18_240 VPWR VGND gf180mcu_fd_sc_mcu7t5v0__filltie
XTAP_TAPCELL_ROW_24_298 VPWR VGND gf180mcu_fd_sc_mcu7t5v0__filltie
X_320_ _330_/B _329_/B VPWR VPWR VGND VGND gf180mcu_fd_sc_mcu7t5v0__clkinv_1
XFILLER_10_454 VPWR VPWR VGND VGND gf180mcu_fd_sc_mcu7t5v0__fill_1
XFILLER_10_465 VPWR VPWR VGND VGND gf180mcu_fd_sc_mcu7t5v0__fillcap_16
XFILLER_38_70 VPWR VPWR VGND VGND gf180mcu_fd_sc_mcu7t5v0__fillcap_8
XTAP_TAPCELL_ROW_0_87 VPWR VGND gf180mcu_fd_sc_mcu7t5v0__filltie
XTAP_TAPCELL_ROW_15_221 VPWR VGND gf180mcu_fd_sc_mcu7t5v0__filltie
X_518_ _495_/B _537_/A2 _505_/C _526_/A2 _520_/C VPWR VPWR VGND VGND gf180mcu_fd_sc_mcu7t5v0__aoi22_2
XFILLER_33_579 VPWR VPWR VGND VGND gf180mcu_fd_sc_mcu7t5v0__fillcap_16
X_449_ _449_/A1 _506_/A1 _449_/A3 _481_/A1 VPWR VPWR VGND VGND gf180mcu_fd_sc_mcu7t5v0__nand3_2
XFILLER_32_590 VPWR VPWR VGND VGND gf180mcu_fd_sc_mcu7t5v0__fillcap_4
XTAP_TAPCELL_ROW_21_268 VPWR VGND gf180mcu_fd_sc_mcu7t5v0__filltie
Xload_slew17 _476_/A1 _454_/B VPWR VPWR VGND VGND gf180mcu_fd_sc_mcu7t5v0__buf_2
XFILLER_15_557 VPWR VPWR VGND VGND gf180mcu_fd_sc_mcu7t5v0__fill_2
XTAP_TAPCELL_ROW_29_335 VPWR VGND gf180mcu_fd_sc_mcu7t5v0__filltie
XPHY_EDGE_ROW_23_Left_62 VPWR VGND gf180mcu_fd_sc_mcu7t5v0__endcap
XTAP_TAPCELL_ROW_34_382 VPWR VGND gf180mcu_fd_sc_mcu7t5v0__filltie
XFILLER_19_72 VPWR VPWR VGND VGND gf180mcu_fd_sc_mcu7t5v0__fillcap_64
XFILLER_34_107 VPWR VPWR VGND VGND gf180mcu_fd_sc_mcu7t5v0__fillcap_64
XFILLER_18_2 VPWR VPWR VGND VGND gf180mcu_fd_sc_mcu7t5v0__fillcap_32
XTAP_TAPCELL_ROW_31_352 VPWR VGND gf180mcu_fd_sc_mcu7t5v0__filltie
XFILLER_0_206 VPWR VPWR VGND VGND gf180mcu_fd_sc_mcu7t5v0__fillcap_32
XFILLER_16_107 VPWR VPWR VGND VGND gf180mcu_fd_sc_mcu7t5v0__fillcap_64
XFILLER_8_317 VPWR VPWR VGND VGND gf180mcu_fd_sc_mcu7t5v0__fillcap_16
XFILLER_38_210 VPWR VPWR VGND VGND gf180mcu_fd_sc_mcu7t5v0__fill_2
XTAP_TAPCELL_ROW_36_400 VPWR VGND gf180mcu_fd_sc_mcu7t5v0__filltie
XPHY_EDGE_ROW_5_Right_5 VPWR VGND gf180mcu_fd_sc_mcu7t5v0__endcap
XTAP_TAPCELL_ROW_8_158 VPWR VGND gf180mcu_fd_sc_mcu7t5v0__filltie
X_551_ _555_/A1 _322_/I _585_/A2 VPWR VPWR VGND VGND gf180mcu_fd_sc_mcu7t5v0__nor2_4
X_620_ _620_/D _638_/CLK _620_/Q VPWR VPWR VGND VGND gf180mcu_fd_sc_mcu7t5v0__dffq_1
XFILLER_9_604 VPWR VPWR VGND VGND gf180mcu_fd_sc_mcu7t5v0__fill_1
X_482_ _471_/B _388_/Z _482_/B _483_/A2 VPWR VPWR VGND VGND gf180mcu_fd_sc_mcu7t5v0__aoi21_1
X_603_ _603_/A1 _603_/A2 _603_/B _641_/D VPWR VPWR VGND VGND gf180mcu_fd_sc_mcu7t5v0__aoi21_1
X_465_ _505_/A2 _496_/A2 _465_/B _468_/C _466_/A1 VPWR VPWR VGND VGND gf180mcu_fd_sc_mcu7t5v0__oai211_1
XFILLER_27_72 VPWR VPWR VGND VGND gf180mcu_fd_sc_mcu7t5v0__fillcap_64
X_534_ _468_/C _488_/B _534_/B _535_/A2 VPWR VPWR VGND VGND gf180mcu_fd_sc_mcu7t5v0__oai21_2
XFILLER_9_489 VPWR VPWR VGND VGND gf180mcu_fd_sc_mcu7t5v0__fill_1
XFILLER_13_496 VPWR VPWR VGND VGND gf180mcu_fd_sc_mcu7t5v0__fill_1
X_396_ _396_/A1 _396_/A2 _396_/B _396_/C _423_/C VPWR VPWR VGND VGND gf180mcu_fd_sc_mcu7t5v0__aoi211_4
XTAP_TAPCELL_ROW_10_174 VPWR VGND gf180mcu_fd_sc_mcu7t5v0__filltie
XTAP_TAPCELL_ROW_2_109 VPWR VGND gf180mcu_fd_sc_mcu7t5v0__filltie
XTAP_TAPCELL_ROW_18_241 VPWR VGND gf180mcu_fd_sc_mcu7t5v0__filltie
XFILLER_31_260 VPWR VPWR VGND VGND gf180mcu_fd_sc_mcu7t5v0__fillcap_4
XFILLER_27_588 VPWR VPWR VGND VGND gf180mcu_fd_sc_mcu7t5v0__fillcap_16
Xfanout20 _437_/B _516_/C VPWR VPWR VGND VGND gf180mcu_fd_sc_mcu7t5v0__buf_12
XFILLER_1_142 VPWR VPWR VGND VGND gf180mcu_fd_sc_mcu7t5v0__fillcap_64
XTAP_TAPCELL_ROW_0_88 VPWR VGND gf180mcu_fd_sc_mcu7t5v0__filltie
X_448_ _506_/A1 _407_/B _511_/A1 VPWR VPWR VGND VGND gf180mcu_fd_sc_mcu7t5v0__nand2_4
X_517_ _414_/C _532_/A2 _517_/B _526_/A2 VPWR VPWR VGND VGND gf180mcu_fd_sc_mcu7t5v0__aoi21_2
XFILLER_13_282 VPWR VPWR VGND VGND gf180mcu_fd_sc_mcu7t5v0__fillcap_4
X_379_ _643_/Q _375_/C _434_/A3 _375_/B _464_/B VPWR VPWR VGND VGND gf180mcu_fd_sc_mcu7t5v0__nand4_4
XFILLER_5_492 VPWR VPWR VGND VGND gf180mcu_fd_sc_mcu7t5v0__fillcap_64
XTAP_TAPCELL_ROW_21_269 VPWR VGND gf180mcu_fd_sc_mcu7t5v0__filltie
Xload_slew29 _471_/A1 wire28/I VPWR VPWR VGND VGND gf180mcu_fd_sc_mcu7t5v0__buf_2
XFILLER_19_308 VPWR VPWR VGND VGND gf180mcu_fd_sc_mcu7t5v0__fill_1
XTAP_TAPCELL_ROW_29_336 VPWR VGND gf180mcu_fd_sc_mcu7t5v0__filltie
XFILLER_10_241 VPWR VPWR VGND VGND gf180mcu_fd_sc_mcu7t5v0__fillcap_4
XFILLER_2_451 VPWR VPWR VGND VGND gf180mcu_fd_sc_mcu7t5v0__fillcap_4
XFILLER_1_66 VPWR VPWR VGND VGND gf180mcu_fd_sc_mcu7t5v0__fillcap_4
XFILLER_36_171 VPWR VPWR VGND VGND gf180mcu_fd_sc_mcu7t5v0__fillcap_4
XFILLER_20_583 VPWR VPWR VGND VGND gf180mcu_fd_sc_mcu7t5v0__fillcap_8
XTAP_TAPCELL_ROW_34_383 VPWR VGND gf180mcu_fd_sc_mcu7t5v0__filltie
XFILLER_35_72 VPWR VPWR VGND VGND gf180mcu_fd_sc_mcu7t5v0__fillcap_64
XFILLER_11_594 VPWR VPWR VGND VGND gf180mcu_fd_sc_mcu7t5v0__fillcap_8
XFILLER_18_171 VPWR VPWR VGND VGND gf180mcu_fd_sc_mcu7t5v0__fillcap_4
XTAP_TAPCELL_ROW_31_353 VPWR VGND gf180mcu_fd_sc_mcu7t5v0__filltie
XFILLER_12_314 VPWR VPWR VGND VGND gf180mcu_fd_sc_mcu7t5v0__fill_1
XFILLER_35_417 VPWR VPWR VGND VGND gf180mcu_fd_sc_mcu7t5v0__fill_2
XFILLER_30_177 VPWR VPWR VGND VGND gf180mcu_fd_sc_mcu7t5v0__fillcap_64
XFILLER_30_2 VPWR VPWR VGND VGND gf180mcu_fd_sc_mcu7t5v0__fillcap_32
XTAP_TAPCELL_ROW_8_159 VPWR VGND gf180mcu_fd_sc_mcu7t5v0__filltie
X_481_ _481_/A1 _481_/A2 _481_/B _482_/B VPWR VPWR VGND VGND gf180mcu_fd_sc_mcu7t5v0__aoi21_2
X_550_ _649_/D _541_/B _550_/B _625_/D VPWR VPWR VGND VGND gf180mcu_fd_sc_mcu7t5v0__aoi21_2
XFILLER_29_244 VPWR VPWR VGND VGND gf180mcu_fd_sc_mcu7t5v0__fillcap_16
XFILLER_12_177 VPWR VPWR VGND VGND gf180mcu_fd_sc_mcu7t5v0__fillcap_64
XPHY_EDGE_ROW_11_Right_11 VPWR VGND gf180mcu_fd_sc_mcu7t5v0__endcap
XFILLER_25_494 VPWR VPWR VGND VGND gf180mcu_fd_sc_mcu7t5v0__fill_1
XFILLER_4_387 VPWR VPWR VGND VGND gf180mcu_fd_sc_mcu7t5v0__fillcap_64
XPHY_EDGE_ROW_20_Right_20 VPWR VGND gf180mcu_fd_sc_mcu7t5v0__endcap
XTAP_TAPCELL_ROW_5_129 VPWR VGND gf180mcu_fd_sc_mcu7t5v0__filltie
XFILLER_26_247 VPWR VPWR VGND VGND gf180mcu_fd_sc_mcu7t5v0__fillcap_16
XFILLER_1_346 VPWR VPWR VGND VGND gf180mcu_fd_sc_mcu7t5v0__fillcap_4
X_602_ _641_/Q _602_/A2 _603_/A2 VPWR VPWR VGND VGND gf180mcu_fd_sc_mcu7t5v0__nand2_1
X_464_ _464_/A1 _407_/B _464_/B _464_/C _465_/B VPWR VPWR VGND VGND gf180mcu_fd_sc_mcu7t5v0__oai211_4
X_533_ _533_/A1 _533_/A2 _541_/B _540_/A1 VPWR VPWR VGND VGND gf180mcu_fd_sc_mcu7t5v0__nor3_1
XTAP_TAPCELL_ROW_10_175 VPWR VGND gf180mcu_fd_sc_mcu7t5v0__filltie
X_395_ wire55/I _454_/A2 _454_/B _489_/A1 _481_/B _418_/A3 VPWR VPWR VGND VGND gf180mcu_fd_sc_mcu7t5v0__aoi221_4
XTAP_TAPCELL_ROW_18_242 VPWR VGND gf180mcu_fd_sc_mcu7t5v0__filltie
XFILLER_23_206 VPWR VPWR VGND VGND gf180mcu_fd_sc_mcu7t5v0__fillcap_4
Xclkbuf_3_2__f_clk clkbuf_0_clk/Z _645_/CLK VPWR VPWR VGND VGND gf180mcu_fd_sc_mcu7t5v0__clkbuf_8
Xfanout21 _646_/D _505_/C VPWR VPWR VGND VGND gf180mcu_fd_sc_mcu7t5v0__buf_8
XFILLER_6_449 VPWR VPWR VGND VGND gf180mcu_fd_sc_mcu7t5v0__fillcap_4
XFILLER_8_2 VPWR VPWR VGND VGND gf180mcu_fd_sc_mcu7t5v0__fillcap_32
XTAP_TAPCELL_ROW_0_78 VPWR VGND gf180mcu_fd_sc_mcu7t5v0__filltie
XTAP_TAPCELL_ROW_0_89 VPWR VGND gf180mcu_fd_sc_mcu7t5v0__filltie
XFILLER_38_83 VPWR VPWR VGND VGND gf180mcu_fd_sc_mcu7t5v0__fillcap_8
XFILLER_38_61 VPWR VPWR VGND VGND gf180mcu_fd_sc_mcu7t5v0__fill_2
XFILLER_18_523 VPWR VPWR VGND VGND gf180mcu_fd_sc_mcu7t5v0__fill_2
X_447_ _490_/A1 _523_/A3 _532_/A2 VPWR VPWR VGND VGND gf180mcu_fd_sc_mcu7t5v0__nor2_4
X_378_ wire67/I _370_/Z _559_/B _378_/A4 _378_/ZN VPWR VPWR VGND VGND gf180mcu_fd_sc_mcu7t5v0__nor4_4
X_516_ _516_/A1 _490_/B _516_/B _516_/C _517_/B VPWR VPWR VGND VGND gf180mcu_fd_sc_mcu7t5v0__aoi211_2
XFILLER_9_276 VPWR VPWR VGND VGND gf180mcu_fd_sc_mcu7t5v0__fillcap_4
XTAP_TAPCELL_ROW_29_337 VPWR VGND gf180mcu_fd_sc_mcu7t5v0__filltie
XFILLER_15_559 VPWR VPWR VGND VGND gf180mcu_fd_sc_mcu7t5v0__fill_1
XTAP_TAPCELL_ROW_26_307 VPWR VGND gf180mcu_fd_sc_mcu7t5v0__filltie
XFILLER_11_540 VPWR VPWR VGND VGND gf180mcu_fd_sc_mcu7t5v0__fillcap_16
XFILLER_11_562 VPWR VPWR VGND VGND gf180mcu_fd_sc_mcu7t5v0__fillcap_32
XFILLER_33_142 VPWR VPWR VGND VGND gf180mcu_fd_sc_mcu7t5v0__fillcap_64
XTAP_TAPCELL_ROW_31_354 VPWR VGND gf180mcu_fd_sc_mcu7t5v0__filltie
XFILLER_29_448 VPWR VPWR VGND VGND gf180mcu_fd_sc_mcu7t5v0__fill_2
Xmax_cap40 _437_/A1 _458_/A1 VPWR VPWR VGND VGND gf180mcu_fd_sc_mcu7t5v0__buf_8
XFILLER_15_142 VPWR VPWR VGND VGND gf180mcu_fd_sc_mcu7t5v0__fillcap_64
XFILLER_30_101 VPWR VPWR VGND VGND gf180mcu_fd_sc_mcu7t5v0__fillcap_4
XFILLER_31_602 VPWR VPWR VGND VGND gf180mcu_fd_sc_mcu7t5v0__fill_2
XFILLER_7_352 VPWR VPWR VGND VGND gf180mcu_fd_sc_mcu7t5v0__fillcap_4
XFILLER_7_66 VPWR VPWR VGND VGND gf180mcu_fd_sc_mcu7t5v0__fillcap_4
XFILLER_23_2 VPWR VPWR VGND VGND gf180mcu_fd_sc_mcu7t5v0__fillcap_64
XFILLER_29_212 VPWR VPWR VGND VGND gf180mcu_fd_sc_mcu7t5v0__fillcap_32
X_480_ _502_/B _480_/A2 _480_/B1 _648_/D _483_/B VPWR VPWR VGND VGND gf180mcu_fd_sc_mcu7t5v0__aoi22_2
XFILLER_12_101 VPWR VPWR VGND VGND gf180mcu_fd_sc_mcu7t5v0__fillcap_4
XFILLER_13_602 VPWR VPWR VGND VGND gf180mcu_fd_sc_mcu7t5v0__fill_2
XFILLER_4_311 VPWR VPWR VGND VGND gf180mcu_fd_sc_mcu7t5v0__fillcap_4
X_601_ _601_/A1 _601_/A2 _601_/B _640_/D VPWR VPWR VGND VGND gf180mcu_fd_sc_mcu7t5v0__aoi21_1
X_463_ _463_/A1 _505_/C _475_/A2 _469_/A1 VPWR VPWR VGND VGND gf180mcu_fd_sc_mcu7t5v0__nand3_2
X_394_ _464_/A1 _523_/A3 _489_/A1 VPWR VPWR VGND VGND gf180mcu_fd_sc_mcu7t5v0__nand2_4
X_532_ _645_/D _532_/A2 _532_/B _532_/C _533_/A1 VPWR VPWR VGND VGND gf180mcu_fd_sc_mcu7t5v0__aoi211_2
XTAP_TAPCELL_ROW_10_176 VPWR VGND gf180mcu_fd_sc_mcu7t5v0__filltie
XFILLER_4_34 VPWR VPWR VGND VGND gf180mcu_fd_sc_mcu7t5v0__fill_1
XTAP_TAPCELL_ROW_18_243 VPWR VGND gf180mcu_fd_sc_mcu7t5v0__filltie
XTAP_TAPCELL_ROW_1_100 VPWR VGND gf180mcu_fd_sc_mcu7t5v0__filltie
XFILLER_27_524 VPWR VPWR VGND VGND gf180mcu_fd_sc_mcu7t5v0__fill_2
Xfanout22 _646_/D _532_/C VPWR VPWR VGND VGND gf180mcu_fd_sc_mcu7t5v0__buf_2
Xfanout88 _554_/ZN _586_/B1 VPWR VPWR VGND VGND gf180mcu_fd_sc_mcu7t5v0__buf_2
XFILLER_6_406 VPWR VPWR VGND VGND gf180mcu_fd_sc_mcu7t5v0__fillcap_4
XTAP_TAPCELL_ROW_0_79 VPWR VGND gf180mcu_fd_sc_mcu7t5v0__filltie
X_515_ _505_/C _515_/A2 _515_/B _537_/A2 VPWR VPWR VGND VGND gf180mcu_fd_sc_mcu7t5v0__oai21_4
X_446_ _388_/Z _471_/A3 _446_/B _453_/A1 VPWR VPWR VGND VGND gf180mcu_fd_sc_mcu7t5v0__oai21_4
X_377_ _391_/A2 wire67/Z _399_/B _559_/B _449_/A1 VPWR VPWR VGND VGND gf180mcu_fd_sc_mcu7t5v0__oai22_4
XTAP_TAPCELL_ROW_29_338 VPWR VGND gf180mcu_fd_sc_mcu7t5v0__filltie
XFILLER_6_247 VPWR VPWR VGND VGND gf180mcu_fd_sc_mcu7t5v0__fillcap_64
XTAP_TAPCELL_ROW_20_260 VPWR VGND gf180mcu_fd_sc_mcu7t5v0__filltie
XFILLER_18_387 VPWR VPWR VGND VGND gf180mcu_fd_sc_mcu7t5v0__fill_1
XFILLER_14_593 VPWR VPWR VGND VGND gf180mcu_fd_sc_mcu7t5v0__fill_2
X_429_ _431_/A2 _429_/A2 _430_/A1 VPWR VPWR VGND VGND gf180mcu_fd_sc_mcu7t5v0__nor2_1
Xinput1 rst_n input1/Z VPWR VPWR VGND VGND gf180mcu_fd_sc_mcu7t5v0__buf_1
XTAP_TAPCELL_ROW_26_308 VPWR VGND gf180mcu_fd_sc_mcu7t5v0__filltie
XFILLER_28_107 VPWR VPWR VGND VGND gf180mcu_fd_sc_mcu7t5v0__fillcap_64
XFILLER_3_206 VPWR VPWR VGND VGND gf180mcu_fd_sc_mcu7t5v0__fillcap_4
XFILLER_7_556 VPWR VPWR VGND VGND gf180mcu_fd_sc_mcu7t5v0__fillcap_4
XPHY_EDGE_ROW_27_Left_66 VPWR VGND gf180mcu_fd_sc_mcu7t5v0__endcap
XTAP_TAPCELL_ROW_31_355 VPWR VGND gf180mcu_fd_sc_mcu7t5v0__filltie
XFILLER_35_419 VPWR VPWR VGND VGND gf180mcu_fd_sc_mcu7t5v0__fill_1
Xmax_cap41 max_cap41/I _437_/A1 VPWR VPWR VGND VGND gf180mcu_fd_sc_mcu7t5v0__buf_8
XFILLER_7_397 VPWR VPWR VGND VGND gf180mcu_fd_sc_mcu7t5v0__fill_1
XFILLER_11_371 VPWR VPWR VGND VGND gf180mcu_fd_sc_mcu7t5v0__fill_2
XFILLER_16_2 VPWR VPWR VGND VGND gf180mcu_fd_sc_mcu7t5v0__fillcap_32
Xclone130 _437_/B _414_/C VPWR VPWR VGND VGND gf180mcu_fd_sc_mcu7t5v0__buf_4
XFILLER_34_452 VPWR VPWR VGND VGND gf180mcu_fd_sc_mcu7t5v0__fill_2
XTAP_TAPCELL_ROW_7_150 VPWR VGND gf180mcu_fd_sc_mcu7t5v0__filltie
XPHY_EDGE_ROW_9_Right_9 VPWR VGND gf180mcu_fd_sc_mcu7t5v0__endcap
XPHY_EDGE_ROW_14_Left_53 VPWR VGND gf180mcu_fd_sc_mcu7t5v0__endcap
XTAP_TAPCELL_ROW_4_120 VPWR VGND gf180mcu_fd_sc_mcu7t5v0__filltie
X_600_ _640_/Q _602_/A2 _601_/A2 VPWR VPWR VGND VGND gf180mcu_fd_sc_mcu7t5v0__nand2_1
X_531_ _649_/D _531_/A2 _531_/A3 _531_/B _622_/D VPWR VPWR VGND VGND gf180mcu_fd_sc_mcu7t5v0__oai31_1
XFILLER_9_426 VPWR VPWR VGND VGND gf180mcu_fd_sc_mcu7t5v0__fill_2
X_393_ _516_/C _516_/A1 _471_/A2 VPWR VPWR VGND VGND gf180mcu_fd_sc_mcu7t5v0__nand2_1
XFILLER_13_422 VPWR VPWR VGND VGND gf180mcu_fd_sc_mcu7t5v0__fill_2
XFILLER_13_488 VPWR VPWR VGND VGND gf180mcu_fd_sc_mcu7t5v0__fill_2
X_462_ _506_/B _462_/A2 _506_/A1 _490_/B _475_/A2 VPWR VPWR VGND VGND gf180mcu_fd_sc_mcu7t5v0__nand4_4
XFILLER_25_260 VPWR VPWR VGND VGND gf180mcu_fd_sc_mcu7t5v0__fillcap_8
XTAP_TAPCELL_ROW_10_177 VPWR VGND gf180mcu_fd_sc_mcu7t5v0__filltie
XFILLER_16_271 VPWR VPWR VGND VGND gf180mcu_fd_sc_mcu7t5v0__fillcap_4
XTAP_TAPCELL_ROW_18_244 VPWR VGND gf180mcu_fd_sc_mcu7t5v0__filltie
XTAP_TAPCELL_ROW_1_101 VPWR VGND gf180mcu_fd_sc_mcu7t5v0__filltie
XFILLER_22_241 VPWR VPWR VGND VGND gf180mcu_fd_sc_mcu7t5v0__fillcap_4
Xfanout89 _554_/ZN _582_/B1 VPWR VPWR VGND VGND gf180mcu_fd_sc_mcu7t5v0__buf_1
XFILLER_13_66 VPWR VPWR VGND VGND gf180mcu_fd_sc_mcu7t5v0__fillcap_4
XFILLER_38_52 VPWR VPWR VGND VGND gf180mcu_fd_sc_mcu7t5v0__fill_1
XFILLER_38_63 VPWR VPWR VGND VGND gf180mcu_fd_sc_mcu7t5v0__fill_1
XFILLER_38_96 VPWR VPWR VGND VGND gf180mcu_fd_sc_mcu7t5v0__fillcap_4
XTAP_TAPCELL_ROW_15_214 VPWR VGND gf180mcu_fd_sc_mcu7t5v0__filltie
X_514_ _505_/C _515_/A2 _514_/Z VPWR VPWR VGND VGND gf180mcu_fd_sc_mcu7t5v0__or2_1
XFILLER_9_212 VPWR VPWR VGND VGND gf180mcu_fd_sc_mcu7t5v0__fillcap_64
X_445_ _410_/B _445_/A2 _445_/B _515_/B _457_/A2 VPWR VPWR VGND VGND gf180mcu_fd_sc_mcu7t5v0__aoi211_4
X_376_ _396_/A1 _396_/A2 _400_/B _400_/C _422_/C VPWR VPWR VGND VGND gf180mcu_fd_sc_mcu7t5v0__aoi22_4
XFILLER_32_594 VPWR VPWR VGND VGND gf180mcu_fd_sc_mcu7t5v0__fill_1
XTAP_TAPCELL_ROW_29_339 VPWR VGND gf180mcu_fd_sc_mcu7t5v0__filltie
XTAP_TAPCELL_ROW_20_261 VPWR VGND gf180mcu_fd_sc_mcu7t5v0__filltie
XFILLER_18_366 VPWR VPWR VGND VGND gf180mcu_fd_sc_mcu7t5v0__fill_1
X_428_ _516_/A1 _428_/A2 _429_/A2 VPWR VPWR VGND VGND gf180mcu_fd_sc_mcu7t5v0__nor2_1
X_359_ _361_/A3 _361_/A4 _400_/C _359_/ZN VPWR VPWR VGND VGND gf180mcu_fd_sc_mcu7t5v0__nand3_4
XTAP_TAPCELL_ROW_26_309 VPWR VGND gf180mcu_fd_sc_mcu7t5v0__filltie
Xinput2 ui_in[0] input2/Z VPWR VPWR VGND VGND gf180mcu_fd_sc_mcu7t5v0__buf_1
XFILLER_20_520 VPWR VPWR VGND VGND gf180mcu_fd_sc_mcu7t5v0__fill_1
XTAP_TAPCELL_ROW_34_375 VPWR VGND gf180mcu_fd_sc_mcu7t5v0__filltie
XFILLER_10_34 VPWR VPWR VGND VGND gf180mcu_fd_sc_mcu7t5v0__fill_1
XFILLER_20_597 VPWR VPWR VGND VGND gf180mcu_fd_sc_mcu7t5v0__fillcap_8
XFILLER_30_317 VPWR VPWR VGND VGND gf180mcu_fd_sc_mcu7t5v0__fill_2
XPHY_EDGE_ROW_2_Left_41 VPWR VGND gf180mcu_fd_sc_mcu7t5v0__endcap
XTAP_TAPCELL_ROW_31_356 VPWR VGND gf180mcu_fd_sc_mcu7t5v0__filltie
XFILLER_12_317 VPWR VPWR VGND VGND gf180mcu_fd_sc_mcu7t5v0__fill_1
XFILLER_24_177 VPWR VPWR VGND VGND gf180mcu_fd_sc_mcu7t5v0__fillcap_64
XFILLER_4_527 VPWR VPWR VGND VGND gf180mcu_fd_sc_mcu7t5v0__fillcap_64
XFILLER_21_66 VPWR VPWR VGND VGND gf180mcu_fd_sc_mcu7t5v0__fillcap_4
Xmax_cap31 _516_/B _443_/A3 VPWR VPWR VGND VGND gf180mcu_fd_sc_mcu7t5v0__buf_2
XFILLER_31_604 VPWR VPWR VGND VGND gf180mcu_fd_sc_mcu7t5v0__fill_1
XFILLER_21_136 VPWR VPWR VGND VGND gf180mcu_fd_sc_mcu7t5v0__fillcap_4
XFILLER_8_107 VPWR VPWR VGND VGND gf180mcu_fd_sc_mcu7t5v0__fillcap_64
XFILLER_13_604 VPWR VPWR VGND VGND gf180mcu_fd_sc_mcu7t5v0__fill_1
XTAP_TAPCELL_ROW_7_151 VPWR VGND gf180mcu_fd_sc_mcu7t5v0__filltie
XFILLER_0_596 VPWR VPWR VGND VGND gf180mcu_fd_sc_mcu7t5v0__fillcap_8
XFILLER_35_206 VPWR VPWR VGND VGND gf180mcu_fd_sc_mcu7t5v0__fillcap_4
XFILLER_35_228 VPWR VPWR VGND VGND gf180mcu_fd_sc_mcu7t5v0__fill_2
XTAP_TAPCELL_ROW_13_197 VPWR VGND gf180mcu_fd_sc_mcu7t5v0__filltie
XTAP_TAPCELL_ROW_4_121 VPWR VGND gf180mcu_fd_sc_mcu7t5v0__filltie
X_461_ _437_/B _468_/A2 _473_/A2 VPWR VPWR VGND VGND gf180mcu_fd_sc_mcu7t5v0__nor2_1
XFILLER_17_206 VPWR VPWR VGND VGND gf180mcu_fd_sc_mcu7t5v0__fillcap_4
X_530_ _530_/A1 _530_/A2 _648_/D _531_/A3 VPWR VPWR VGND VGND gf180mcu_fd_sc_mcu7t5v0__aoi21_1
X_392_ _506_/B wire34/Z _476_/A1 VPWR VPWR VGND VGND gf180mcu_fd_sc_mcu7t5v0__nor2_4
XFILLER_25_272 VPWR VPWR VGND VGND gf180mcu_fd_sc_mcu7t5v0__fill_2
XTAP_TAPCELL_ROW_10_178 VPWR VGND gf180mcu_fd_sc_mcu7t5v0__filltie
XPHY_EDGE_ROW_31_Left_70 VPWR VGND gf180mcu_fd_sc_mcu7t5v0__endcap
XTAP_TAPCELL_ROW_18_245 VPWR VGND gf180mcu_fd_sc_mcu7t5v0__filltie
XTAP_TAPCELL_ROW_1_102 VPWR VGND gf180mcu_fd_sc_mcu7t5v0__filltie
XFILLER_27_526 VPWR VPWR VGND VGND gf180mcu_fd_sc_mcu7t5v0__fill_1
XFILLER_27_559 VPWR VPWR VGND VGND gf180mcu_fd_sc_mcu7t5v0__fill_1
XFILLER_35_581 VPWR VPWR VGND VGND gf180mcu_fd_sc_mcu7t5v0__fillcap_16
X_444_ _478_/A1 _477_/A2 _445_/A2 VPWR VPWR VGND VGND gf180mcu_fd_sc_mcu7t5v0__nand2_2
XTAP_TAPCELL_ROW_15_215 VPWR VGND gf180mcu_fd_sc_mcu7t5v0__filltie
X_513_ _498_/Z _513_/A2 _513_/A3 _513_/B1 _513_/B2 _621_/D VPWR VPWR VGND VGND gf180mcu_fd_sc_mcu7t5v0__oai32_4
X_375_ _364_/B _433_/A3 _375_/B _375_/C _421_/B VPWR VPWR VGND VGND gf180mcu_fd_sc_mcu7t5v0__oai211_2
XFILLER_5_463 VPWR VPWR VGND VGND gf180mcu_fd_sc_mcu7t5v0__fillcap_16
XTAP_TAPCELL_ROW_20_262 VPWR VGND gf180mcu_fd_sc_mcu7t5v0__filltie
XFILLER_6_2 VPWR VPWR VGND VGND gf180mcu_fd_sc_mcu7t5v0__fillcap_32
X_358_ _383_/A1 _385_/A2 _358_/B _361_/A4 VPWR VPWR VGND VGND gf180mcu_fd_sc_mcu7t5v0__oai21_4
X_427_ _428_/A2 _544_/A2 _484_/B _431_/A2 VPWR VPWR VGND VGND gf180mcu_fd_sc_mcu7t5v0__oai21_1
XFILLER_5_282 VPWR VPWR VGND VGND gf180mcu_fd_sc_mcu7t5v0__fillcap_64
Xtt_um_r2r_dac_digital_95 uio_oe[1] VPWR VPWR VGND VGND gf180mcu_fd_sc_mcu7t5v0__tieh
XPHY_EDGE_ROW_18_Right_18 VPWR VGND gf180mcu_fd_sc_mcu7t5v0__endcap
Xinput3 ui_in[1] input3/Z VPWR VPWR VGND VGND gf180mcu_fd_sc_mcu7t5v0__buf_1
XPHY_EDGE_ROW_27_Right_27 VPWR VGND gf180mcu_fd_sc_mcu7t5v0__endcap
XTAP_TAPCELL_ROW_34_376 VPWR VGND gf180mcu_fd_sc_mcu7t5v0__filltie
XPHY_EDGE_ROW_36_Right_36 VPWR VGND gf180mcu_fd_sc_mcu7t5v0__endcap
XFILLER_19_66 VPWR VPWR VGND VGND gf180mcu_fd_sc_mcu7t5v0__fillcap_4
XFILLER_27_142 VPWR VPWR VGND VGND gf180mcu_fd_sc_mcu7t5v0__fillcap_64
XFILLER_2_241 VPWR VPWR VGND VGND gf180mcu_fd_sc_mcu7t5v0__fillcap_4
XTAP_TAPCELL_ROW_31_357 VPWR VGND gf180mcu_fd_sc_mcu7t5v0__filltie
XFILLER_6_591 VPWR VPWR VGND VGND gf180mcu_fd_sc_mcu7t5v0__fillcap_4
XFILLER_24_101 VPWR VPWR VGND VGND gf180mcu_fd_sc_mcu7t5v0__fillcap_4
XFILLER_11_373 VPWR VPWR VGND VGND gf180mcu_fd_sc_mcu7t5v0__fill_1
XFILLER_7_377 VPWR VPWR VGND VGND gf180mcu_fd_sc_mcu7t5v0__fillcap_4
XFILLER_3_594 VPWR VPWR VGND VGND gf180mcu_fd_sc_mcu7t5v0__fillcap_8
XFILLER_34_454 VPWR VPWR VGND VGND gf180mcu_fd_sc_mcu7t5v0__fill_1
XFILLER_16_34 VPWR VPWR VGND VGND gf180mcu_fd_sc_mcu7t5v0__fill_1
XPHY_EDGE_ROW_0_Right_0 VPWR VGND gf180mcu_fd_sc_mcu7t5v0__endcap
XTAP_TAPCELL_ROW_7_152 VPWR VGND gf180mcu_fd_sc_mcu7t5v0__filltie
XTAP_TAPCELL_ROW_13_198 VPWR VGND gf180mcu_fd_sc_mcu7t5v0__filltie
XFILLER_21_2 VPWR VPWR VGND VGND gf180mcu_fd_sc_mcu7t5v0__fillcap_64
XFILLER_34_251 VPWR VPWR VGND VGND gf180mcu_fd_sc_mcu7t5v0__fill_2
XTAP_TAPCELL_ROW_4_122 VPWR VGND gf180mcu_fd_sc_mcu7t5v0__filltie
XFILLER_13_424 VPWR VPWR VGND VGND gf180mcu_fd_sc_mcu7t5v0__fill_1
X_391_ wire67/Z _391_/A2 _396_/B _396_/C _516_/A1 VPWR VPWR VGND VGND gf180mcu_fd_sc_mcu7t5v0__oai22_4
X_460_ _506_/B _490_/B _538_/A2 VPWR VPWR VGND VGND gf180mcu_fd_sc_mcu7t5v0__nand2_2
XFILLER_27_66 VPWR VPWR VGND VGND gf180mcu_fd_sc_mcu7t5v0__fillcap_4
XFILLER_9_428 VPWR VPWR VGND VGND gf180mcu_fd_sc_mcu7t5v0__fill_1
XFILLER_4_177 VPWR VPWR VGND VGND gf180mcu_fd_sc_mcu7t5v0__fillcap_64
XFILLER_4_37 VPWR VPWR VGND VGND gf180mcu_fd_sc_mcu7t5v0__fillcap_64
XTAP_TAPCELL_ROW_10_179 VPWR VGND gf180mcu_fd_sc_mcu7t5v0__filltie
X_589_ _589_/A1 _589_/A2 _601_/B _634_/D VPWR VPWR VGND VGND gf180mcu_fd_sc_mcu7t5v0__aoi21_1
XTAP_TAPCELL_ROW_18_246 VPWR VGND gf180mcu_fd_sc_mcu7t5v0__filltie
XFILLER_8_494 VPWR VPWR VGND VGND gf180mcu_fd_sc_mcu7t5v0__fillcap_16
Xfanout36 _386_/ZN _387_/I VPWR VPWR VGND VGND gf180mcu_fd_sc_mcu7t5v0__buf_8
XFILLER_1_136 VPWR VPWR VGND VGND gf180mcu_fd_sc_mcu7t5v0__fillcap_4
XFILLER_13_276 VPWR VPWR VGND VGND gf180mcu_fd_sc_mcu7t5v0__fillcap_4
X_443_ _437_/B _443_/A2 _443_/A3 wire28/I _452_/A3 VPWR VPWR VGND VGND gf180mcu_fd_sc_mcu7t5v0__nor4_4
XTAP_TAPCELL_ROW_15_216 VPWR VGND gf180mcu_fd_sc_mcu7t5v0__filltie
X_374_ _643_/D _372_/I _454_/A2 VPWR VPWR VGND VGND gf180mcu_fd_sc_mcu7t5v0__nor2_4
X_512_ _513_/B2 _503_/I _513_/A3 VPWR VPWR VGND VGND gf180mcu_fd_sc_mcu7t5v0__nand2_1
XFILLER_26_593 VPWR VPWR VGND VGND gf180mcu_fd_sc_mcu7t5v0__fill_2
XFILLER_5_431 VPWR VPWR VGND VGND gf180mcu_fd_sc_mcu7t5v0__fillcap_32
XTAP_TAPCELL_ROW_23_282 VPWR VGND gf180mcu_fd_sc_mcu7t5v0__filltie
XFILLER_32_574 VPWR VPWR VGND VGND gf180mcu_fd_sc_mcu7t5v0__fillcap_16
XFILLER_24_34 VPWR VPWR VGND VGND gf180mcu_fd_sc_mcu7t5v0__fill_1
XTAP_TAPCELL_ROW_20_263 VPWR VGND gf180mcu_fd_sc_mcu7t5v0__filltie
XTAP_TAPCELL_ROW_28_330 VPWR VGND gf180mcu_fd_sc_mcu7t5v0__filltie
X_357_ _488_/C _646_/D VPWR VPWR VGND VGND gf180mcu_fd_sc_mcu7t5v0__clkinv_16
XFILLER_14_585 VPWR VPWR VGND VGND gf180mcu_fd_sc_mcu7t5v0__fillcap_8
X_426_ _456_/B _544_/A2 VPWR VPWR VGND VGND gf180mcu_fd_sc_mcu7t5v0__clkinv_4
Xtt_um_r2r_dac_digital_96 uio_oe[2] VPWR VPWR VGND VGND gf180mcu_fd_sc_mcu7t5v0__tieh
Xinput4 ui_in[2] input4/Z VPWR VPWR VGND VGND gf180mcu_fd_sc_mcu7t5v0__buf_1
XTAP_TAPCELL_ROW_34_377 VPWR VGND gf180mcu_fd_sc_mcu7t5v0__filltie
XTAP_TAPCELL_ROW_25_300 VPWR VGND gf180mcu_fd_sc_mcu7t5v0__filltie
XFILLER_30_319 VPWR VPWR VGND VGND gf180mcu_fd_sc_mcu7t5v0__fill_1
XFILLER_35_66 VPWR VPWR VGND VGND gf180mcu_fd_sc_mcu7t5v0__fillcap_4
XFILLER_19_600 VPWR VPWR VGND VGND gf180mcu_fd_sc_mcu7t5v0__fillcap_4
X_409_ _516_/C _372_/I _471_/B _410_/B VPWR VPWR VGND VGND gf180mcu_fd_sc_mcu7t5v0__aoi21_4
Xmax_cap44 _462_/A2 _464_/A1 VPWR VPWR VGND VGND gf180mcu_fd_sc_mcu7t5v0__buf_2
XFILLER_7_356 VPWR VPWR VGND VGND gf180mcu_fd_sc_mcu7t5v0__fill_2
XFILLER_11_352 VPWR VPWR VGND VGND gf180mcu_fd_sc_mcu7t5v0__fill_1
XFILLER_3_562 VPWR VPWR VGND VGND gf180mcu_fd_sc_mcu7t5v0__fillcap_32
XFILLER_37_282 VPWR VPWR VGND VGND gf180mcu_fd_sc_mcu7t5v0__fill_2
XFILLER_20_171 VPWR VPWR VGND VGND gf180mcu_fd_sc_mcu7t5v0__fillcap_4
XFILLER_32_34 VPWR VPWR VGND VGND gf180mcu_fd_sc_mcu7t5v0__fill_1
XTAP_TAPCELL_ROW_7_153 VPWR VGND gf180mcu_fd_sc_mcu7t5v0__filltie
XFILLER_7_142 VPWR VPWR VGND VGND gf180mcu_fd_sc_mcu7t5v0__fillcap_64
XTAP_TAPCELL_ROW_13_199 VPWR VGND gf180mcu_fd_sc_mcu7t5v0__filltie
XFILLER_14_2 VPWR VPWR VGND VGND gf180mcu_fd_sc_mcu7t5v0__fillcap_32
XFILLER_34_241 VPWR VPWR VGND VGND gf180mcu_fd_sc_mcu7t5v0__fillcap_4
XTAP_TAPCELL_ROW_4_123 VPWR VGND gf180mcu_fd_sc_mcu7t5v0__filltie
X_390_ _434_/A2 _434_/A3 _390_/B1 _404_/A4 _390_/ZN VPWR VPWR VGND VGND gf180mcu_fd_sc_mcu7t5v0__aoi22_4
XFILLER_25_274 VPWR VPWR VGND VGND gf180mcu_fd_sc_mcu7t5v0__fill_1
XFILLER_5_602 VPWR VPWR VGND VGND gf180mcu_fd_sc_mcu7t5v0__fill_2
XFILLER_4_101 VPWR VPWR VGND VGND gf180mcu_fd_sc_mcu7t5v0__fillcap_4
XFILLER_16_241 VPWR VPWR VGND VGND gf180mcu_fd_sc_mcu7t5v0__fillcap_4
XTAP_TAPCELL_ROW_18_247 VPWR VGND gf180mcu_fd_sc_mcu7t5v0__filltie
X_657_ _657_/D _657_/CLK _657_/Q VPWR VPWR VGND VGND gf180mcu_fd_sc_mcu7t5v0__dffq_1
XFILLER_12_491 VPWR VPWR VGND VGND gf180mcu_fd_sc_mcu7t5v0__fillcap_4
XFILLER_16_263 VPWR VPWR VGND VGND gf180mcu_fd_sc_mcu7t5v0__fillcap_8
XFILLER_31_244 VPWR VPWR VGND VGND gf180mcu_fd_sc_mcu7t5v0__fillcap_16
X_588_ _634_/Q _602_/A2 _589_/A2 VPWR VPWR VGND VGND gf180mcu_fd_sc_mcu7t5v0__nand2_1
XFILLER_8_462 VPWR VPWR VGND VGND gf180mcu_fd_sc_mcu7t5v0__fillcap_32
XPHY_EDGE_ROW_18_Left_57 VPWR VGND gf180mcu_fd_sc_mcu7t5v0__endcap
Xfanout37 _386_/ZN _449_/A3 VPWR VPWR VGND VGND gf180mcu_fd_sc_mcu7t5v0__buf_4
Xfanout15 _647_/D _515_/B VPWR VPWR VGND VGND gf180mcu_fd_sc_mcu7t5v0__buf_8
X_511_ _511_/A1 _529_/A1 _489_/B _511_/B2 _541_/B _513_/A2 VPWR VPWR VGND VGND gf180mcu_fd_sc_mcu7t5v0__aoi221_4
X_442_ _645_/D wire34/Z _477_/A2 VPWR VPWR VGND VGND gf180mcu_fd_sc_mcu7t5v0__nor2_4
XTAP_TAPCELL_ROW_15_217 VPWR VGND gf180mcu_fd_sc_mcu7t5v0__filltie
X_373_ _373_/A1 _378_/A4 wire67/I _559_/B _421_/A1 VPWR VPWR VGND VGND gf180mcu_fd_sc_mcu7t5v0__nor4_4
XFILLER_5_487 VPWR VPWR VGND VGND gf180mcu_fd_sc_mcu7t5v0__fill_2
XTAP_TAPCELL_ROW_23_283 VPWR VGND gf180mcu_fd_sc_mcu7t5v0__filltie
XFILLER_17_594 VPWR VPWR VGND VGND gf180mcu_fd_sc_mcu7t5v0__fillcap_8
XFILLER_32_597 VPWR VPWR VGND VGND gf180mcu_fd_sc_mcu7t5v0__fillcap_8
XFILLER_10_247 VPWR VPWR VGND VGND gf180mcu_fd_sc_mcu7t5v0__fillcap_64
XTAP_TAPCELL_ROW_20_264 VPWR VGND gf180mcu_fd_sc_mcu7t5v0__filltie
XFILLER_2_457 VPWR VPWR VGND VGND gf180mcu_fd_sc_mcu7t5v0__fillcap_64
XFILLER_18_314 VPWR VPWR VGND VGND gf180mcu_fd_sc_mcu7t5v0__fill_1
XFILLER_18_325 VPWR VPWR VGND VGND gf180mcu_fd_sc_mcu7t5v0__fill_2
XTAP_TAPCELL_ROW_28_331 VPWR VGND gf180mcu_fd_sc_mcu7t5v0__filltie
XFILLER_14_553 VPWR VPWR VGND VGND gf180mcu_fd_sc_mcu7t5v0__fillcap_32
XFILLER_14_597 VPWR VPWR VGND VGND gf180mcu_fd_sc_mcu7t5v0__fillcap_8
X_425_ _471_/B _425_/A2 _372_/I _456_/B VPWR VPWR VGND VGND gf180mcu_fd_sc_mcu7t5v0__nand3_4
X_356_ _356_/A1 _400_/C _356_/A3 _356_/ZN VPWR VPWR VGND VGND gf180mcu_fd_sc_mcu7t5v0__nand3_4
Xinput5 ui_in[3] input5/Z VPWR VPWR VGND VGND gf180mcu_fd_sc_mcu7t5v0__buf_1
Xtt_um_r2r_dac_digital_97 uio_oe[3] VPWR VPWR VGND VGND gf180mcu_fd_sc_mcu7t5v0__tieh
XFILLER_36_177 VPWR VPWR VGND VGND gf180mcu_fd_sc_mcu7t5v0__fillcap_32
XFILLER_24_317 VPWR VPWR VGND VGND gf180mcu_fd_sc_mcu7t5v0__fill_1
XTAP_TAPCELL_ROW_34_378 VPWR VGND gf180mcu_fd_sc_mcu7t5v0__filltie
XFILLER_10_37 VPWR VPWR VGND VGND gf180mcu_fd_sc_mcu7t5v0__fillcap_64
XFILLER_20_545 VPWR VPWR VGND VGND gf180mcu_fd_sc_mcu7t5v0__fill_2
XTAP_TAPCELL_ROW_25_301 VPWR VGND gf180mcu_fd_sc_mcu7t5v0__filltie
XFILLER_11_556 VPWR VPWR VGND VGND gf180mcu_fd_sc_mcu7t5v0__fillcap_4
XFILLER_18_177 VPWR VPWR VGND VGND gf180mcu_fd_sc_mcu7t5v0__fillcap_64
X_408_ wire55/I _423_/A1 _410_/A2 VPWR VPWR VGND VGND gf180mcu_fd_sc_mcu7t5v0__nand2_2
XFILLER_33_136 VPWR VPWR VGND VGND gf180mcu_fd_sc_mcu7t5v0__fillcap_4
X_339_ _355_/B _358_/B _366_/A2 _385_/A2 _342_/A3 VPWR VPWR VGND VGND gf180mcu_fd_sc_mcu7t5v0__nor4_4
XFILLER_25_604 VPWR VPWR VGND VGND gf180mcu_fd_sc_mcu7t5v0__fill_1
XPHY_EDGE_ROW_6_Left_45 VPWR VGND gf180mcu_fd_sc_mcu7t5v0__endcap
Xmax_cap45 _449_/A1 _462_/A2 VPWR VPWR VGND VGND gf180mcu_fd_sc_mcu7t5v0__buf_4
XFILLER_15_136 VPWR VPWR VGND VGND gf180mcu_fd_sc_mcu7t5v0__fillcap_4
XFILLER_7_346 VPWR VPWR VGND VGND gf180mcu_fd_sc_mcu7t5v0__fillcap_4
XFILLER_38_206 VPWR VPWR VGND VGND gf180mcu_fd_sc_mcu7t5v0__fillcap_4
XFILLER_29_206 VPWR VPWR VGND VGND gf180mcu_fd_sc_mcu7t5v0__fillcap_4
XFILLER_25_489 VPWR VPWR VGND VGND gf180mcu_fd_sc_mcu7t5v0__fill_1
X_673_ _673_/I uo_out[7] VPWR VPWR VGND VGND gf180mcu_fd_sc_mcu7t5v0__buf_8
XTAP_TAPCELL_ROW_4_124 VPWR VGND gf180mcu_fd_sc_mcu7t5v0__filltie
X_587_ _587_/A1 _587_/A2 _603_/B _633_/D VPWR VPWR VGND VGND gf180mcu_fd_sc_mcu7t5v0__aoi21_2
XFILLER_16_275 VPWR VPWR VGND VGND gf180mcu_fd_sc_mcu7t5v0__fill_2
XFILLER_29_581 VPWR VPWR VGND VGND gf180mcu_fd_sc_mcu7t5v0__fillcap_16
X_656_ _656_/D _656_/CLK _656_/Q VPWR VPWR VGND VGND gf180mcu_fd_sc_mcu7t5v0__dffq_1
XFILLER_31_212 VPWR VPWR VGND VGND gf180mcu_fd_sc_mcu7t5v0__fillcap_32
Xfanout38 _464_/B _506_/A1 VPWR VPWR VGND VGND gf180mcu_fd_sc_mcu7t5v0__buf_8
Xfanout49 fanout49/I _360_/I VPWR VPWR VGND VGND gf180mcu_fd_sc_mcu7t5v0__buf_8
XFILLER_38_78 VPWR VPWR VGND VGND gf180mcu_fd_sc_mcu7t5v0__fill_1
X_441_ _476_/A1 _477_/A1 _441_/B _646_/D _445_/B VPWR VPWR VGND VGND gf180mcu_fd_sc_mcu7t5v0__aoi211_4
X_510_ _510_/A1 _510_/A2 _510_/B _510_/C _513_/B1 VPWR VPWR VGND VGND gf180mcu_fd_sc_mcu7t5v0__aoi211_4
XFILLER_13_212 VPWR VPWR VGND VGND gf180mcu_fd_sc_mcu7t5v0__fillcap_64
XTAP_TAPCELL_ROW_15_218 VPWR VGND gf180mcu_fd_sc_mcu7t5v0__filltie
X_372_ _372_/I _642_/D VPWR VPWR VGND VGND gf180mcu_fd_sc_mcu7t5v0__clkinv_2
XTAP_TAPCELL_ROW_23_284 VPWR VGND gf180mcu_fd_sc_mcu7t5v0__filltie
XPHY_EDGE_ROW_35_Left_74 VPWR VGND gf180mcu_fd_sc_mcu7t5v0__endcap
XFILLER_5_400 VPWR VPWR VGND VGND gf180mcu_fd_sc_mcu7t5v0__fillcap_16
XFILLER_5_422 VPWR VPWR VGND VGND gf180mcu_fd_sc_mcu7t5v0__fill_1
X_639_ _639_/D _656_/CLK _639_/Q VPWR VPWR VGND VGND gf180mcu_fd_sc_mcu7t5v0__dffq_1
XFILLER_17_562 VPWR VPWR VGND VGND gf180mcu_fd_sc_mcu7t5v0__fillcap_32
X_424_ _471_/B _424_/A2 _484_/A1 _424_/B _428_/A2 VPWR VPWR VGND VGND gf180mcu_fd_sc_mcu7t5v0__oai31_4
XTAP_TAPCELL_ROW_28_332 VPWR VGND gf180mcu_fd_sc_mcu7t5v0__filltie
X_355_ _358_/B _366_/A2 _385_/A2 _355_/B _356_/A1 VPWR VPWR VGND VGND gf180mcu_fd_sc_mcu7t5v0__oai31_4
Xtt_um_r2r_dac_digital_98 uio_oe[4] VPWR VPWR VGND VGND gf180mcu_fd_sc_mcu7t5v0__tieh
XFILLER_37_602 VPWR VPWR VGND VGND gf180mcu_fd_sc_mcu7t5v0__fill_2
Xinput6 ui_in[4] input6/Z VPWR VPWR VGND VGND gf180mcu_fd_sc_mcu7t5v0__buf_1
XFILLER_36_101 VPWR VPWR VGND VGND gf180mcu_fd_sc_mcu7t5v0__fillcap_4
XTAP_TAPCELL_ROW_34_379 VPWR VGND gf180mcu_fd_sc_mcu7t5v0__filltie
XTAP_TAPCELL_ROW_25_302 VPWR VGND gf180mcu_fd_sc_mcu7t5v0__filltie
XPHY_EDGE_ROW_14_Right_14 VPWR VGND gf180mcu_fd_sc_mcu7t5v0__endcap
Xclkbuf_3_3__f_clk clkbuf_0_clk/Z _649_/CLK VPWR VPWR VGND VGND gf180mcu_fd_sc_mcu7t5v0__clkbuf_8
XFILLER_4_2 VPWR VPWR VGND VGND gf180mcu_fd_sc_mcu7t5v0__fillcap_32
XPHY_EDGE_ROW_23_Right_23 VPWR VGND gf180mcu_fd_sc_mcu7t5v0__endcap
XFILLER_18_101 VPWR VPWR VGND VGND gf180mcu_fd_sc_mcu7t5v0__fillcap_4
X_407_ _462_/A2 _506_/A1 _407_/B _410_/A1 VPWR VPWR VGND VGND gf180mcu_fd_sc_mcu7t5v0__aoi21_1
XFILLER_14_340 VPWR VPWR VGND VGND gf180mcu_fd_sc_mcu7t5v0__fill_1
X_338_ _645_/Q _384_/A1 _384_/A2 _361_/A3 VPWR VPWR VGND VGND gf180mcu_fd_sc_mcu7t5v0__nand3_4
XPHY_EDGE_ROW_32_Right_32 VPWR VGND gf180mcu_fd_sc_mcu7t5v0__endcap
XFILLER_37_2 VPWR VPWR VGND VGND gf180mcu_fd_sc_mcu7t5v0__fillcap_64
XPHY_EDGE_ROW_22_Left_61 VPWR VGND gf180mcu_fd_sc_mcu7t5v0__endcap
XFILLER_30_107 VPWR VPWR VGND VGND gf180mcu_fd_sc_mcu7t5v0__fillcap_64
XFILLER_7_358 VPWR VPWR VGND VGND gf180mcu_fd_sc_mcu7t5v0__fill_1
XFILLER_37_284 VPWR VPWR VGND VGND gf180mcu_fd_sc_mcu7t5v0__fill_1
XFILLER_12_107 VPWR VPWR VGND VGND gf180mcu_fd_sc_mcu7t5v0__fillcap_64
XFILLER_16_37 VPWR VPWR VGND VGND gf180mcu_fd_sc_mcu7t5v0__fillcap_64
XFILLER_4_317 VPWR VPWR VGND VGND gf180mcu_fd_sc_mcu7t5v0__fillcap_64
XFILLER_0_512 VPWR VPWR VGND VGND gf180mcu_fd_sc_mcu7t5v0__fillcap_32
X_672_ _672_/I uo_out[6] VPWR VPWR VGND VGND gf180mcu_fd_sc_mcu7t5v0__buf_8
XTAP_TAPCELL_ROW_12_190 VPWR VGND gf180mcu_fd_sc_mcu7t5v0__filltie
XPHY_EDGE_ROW_4_Right_4 VPWR VGND gf180mcu_fd_sc_mcu7t5v0__endcap
XTAP_TAPCELL_ROW_4_125 VPWR VGND gf180mcu_fd_sc_mcu7t5v0__filltie
XFILLER_5_604 VPWR VPWR VGND VGND gf180mcu_fd_sc_mcu7t5v0__fill_1
XFILLER_0_342 VPWR VPWR VGND VGND gf180mcu_fd_sc_mcu7t5v0__fillcap_32
X_586_ _641_/Q _586_/A2 _586_/B1 input9/Z _587_/A2 VPWR VPWR VGND VGND gf180mcu_fd_sc_mcu7t5v0__aoi22_1
X_655_ _655_/D _655_/CLK _655_/Q VPWR VPWR VGND VGND gf180mcu_fd_sc_mcu7t5v0__dffq_1
XFILLER_30_290 VPWR VPWR VGND VGND gf180mcu_fd_sc_mcu7t5v0__fill_1
XFILLER_38_57 VPWR VPWR VGND VGND gf180mcu_fd_sc_mcu7t5v0__fillcap_4
X_371_ _373_/A1 _385_/B _372_/I VPWR VPWR VGND VGND gf180mcu_fd_sc_mcu7t5v0__nand2_4
XTAP_TAPCELL_ROW_15_219 VPWR VGND gf180mcu_fd_sc_mcu7t5v0__filltie
X_440_ _462_/A2 _506_/A1 _523_/A3 _477_/A1 VPWR VPWR VGND VGND gf180mcu_fd_sc_mcu7t5v0__nand3_4
XFILLER_26_574 VPWR VPWR VGND VGND gf180mcu_fd_sc_mcu7t5v0__fill_2
XFILLER_9_206 VPWR VPWR VGND VGND gf180mcu_fd_sc_mcu7t5v0__fillcap_4
XTAP_TAPCELL_ROW_23_285 VPWR VGND gf180mcu_fd_sc_mcu7t5v0__filltie
XFILLER_5_489 VPWR VPWR VGND VGND gf180mcu_fd_sc_mcu7t5v0__fill_1
XFILLER_0_172 VPWR VPWR VGND VGND gf180mcu_fd_sc_mcu7t5v0__fillcap_32
X_638_ _638_/D _638_/CLK _638_/Q VPWR VPWR VGND VGND gf180mcu_fd_sc_mcu7t5v0__dffq_1
X_569_ _621_/Q _585_/A2 _586_/A2 _637_/Q _571_/A1 VPWR VPWR VGND VGND gf180mcu_fd_sc_mcu7t5v0__aoi22_1
XFILLER_5_72 VPWR VPWR VGND VGND gf180mcu_fd_sc_mcu7t5v0__fillcap_64
XFILLER_23_522 VPWR VPWR VGND VGND gf180mcu_fd_sc_mcu7t5v0__fill_2
XFILLER_27_349 VPWR VPWR VGND VGND gf180mcu_fd_sc_mcu7t5v0__fill_1
XFILLER_24_37 VPWR VPWR VGND VGND gf180mcu_fd_sc_mcu7t5v0__fillcap_64
XFILLER_18_327 VPWR VPWR VGND VGND gf180mcu_fd_sc_mcu7t5v0__fill_1
X_354_ _502_/B _418_/A1 VPWR VPWR VGND VGND gf180mcu_fd_sc_mcu7t5v0__clkinv_1
X_423_ _423_/A1 _423_/A2 _516_/C _423_/C _484_/A1 VPWR VPWR VGND VGND gf180mcu_fd_sc_mcu7t5v0__aoi211_4
Xtt_um_r2r_dac_digital_99 uio_oe[5] VPWR VPWR VGND VGND gf180mcu_fd_sc_mcu7t5v0__tieh
XTAP_TAPCELL_ROW_1_95 VPWR VGND gf180mcu_fd_sc_mcu7t5v0__filltie
XFILLER_1_492 VPWR VPWR VGND VGND gf180mcu_fd_sc_mcu7t5v0__fillcap_64
Xinput7 ui_in[5] input7/Z VPWR VPWR VGND VGND gf180mcu_fd_sc_mcu7t5v0__buf_1
XTAP_TAPCELL_ROW_25_303 VPWR VGND gf180mcu_fd_sc_mcu7t5v0__filltie
X_406_ _406_/A1 _406_/A2 _475_/B _406_/A4 _406_/Z VPWR VPWR VGND VGND gf180mcu_fd_sc_mcu7t5v0__and4_2
X_337_ _384_/A1 _384_/A2 _404_/A2 VPWR VPWR VGND VGND gf180mcu_fd_sc_mcu7t5v0__nand2_2
XFILLER_10_591 VPWR VPWR VGND VGND gf180mcu_fd_sc_mcu7t5v0__fillcap_4
XFILLER_32_171 VPWR VPWR VGND VGND gf180mcu_fd_sc_mcu7t5v0__fillcap_4
XFILLER_28_466 VPWR VPWR VGND VGND gf180mcu_fd_sc_mcu7t5v0__fill_2
Xinput10 uio_in[0] _322_/I VPWR VPWR VGND VGND gf180mcu_fd_sc_mcu7t5v0__buf_1
XFILLER_14_171 VPWR VPWR VGND VGND gf180mcu_fd_sc_mcu7t5v0__fillcap_4
XFILLER_32_37 VPWR VPWR VGND VGND gf180mcu_fd_sc_mcu7t5v0__fillcap_64
XFILLER_0_546 VPWR VPWR VGND VGND gf180mcu_fd_sc_mcu7t5v0__fillcap_32
X_671_ _671_/I uo_out[5] VPWR VPWR VGND VGND gf180mcu_fd_sc_mcu7t5v0__buf_8
XFILLER_16_436 VPWR VPWR VGND VGND gf180mcu_fd_sc_mcu7t5v0__fill_1
XFILLER_28_241 VPWR VPWR VGND VGND gf180mcu_fd_sc_mcu7t5v0__fillcap_4
XFILLER_28_263 VPWR VPWR VGND VGND gf180mcu_fd_sc_mcu7t5v0__fill_2
XTAP_TAPCELL_ROW_12_191 VPWR VGND gf180mcu_fd_sc_mcu7t5v0__filltie
XTAP_TAPCELL_ROW_4_126 VPWR VGND gf180mcu_fd_sc_mcu7t5v0__filltie
XFILLER_25_244 VPWR VPWR VGND VGND gf180mcu_fd_sc_mcu7t5v0__fillcap_16
XFILLER_0_376 VPWR VPWR VGND VGND gf180mcu_fd_sc_mcu7t5v0__fillcap_32
X_654_ _654_/D _655_/CLK _654_/Q VPWR VPWR VGND VGND gf180mcu_fd_sc_mcu7t5v0__dffq_1
XTAP_TAPCELL_ROW_18_239 VPWR VGND gf180mcu_fd_sc_mcu7t5v0__filltie
X_585_ _625_/Q _585_/A2 _585_/B1 _649_/Q _587_/A1 VPWR VPWR VGND VGND gf180mcu_fd_sc_mcu7t5v0__aoi22_1
XFILLER_12_483 VPWR VPWR VGND VGND gf180mcu_fd_sc_mcu7t5v0__fillcap_8
XFILLER_12_2 VPWR VPWR VGND VGND gf180mcu_fd_sc_mcu7t5v0__fillcap_32
Xfanout18 _644_/D _523_/A3 VPWR VPWR VGND VGND gf180mcu_fd_sc_mcu7t5v0__buf_8
XFILLER_22_247 VPWR VPWR VGND VGND gf180mcu_fd_sc_mcu7t5v0__fillcap_32
XFILLER_35_597 VPWR VPWR VGND VGND gf180mcu_fd_sc_mcu7t5v0__fillcap_8
XFILLER_38_36 VPWR VPWR VGND VGND gf180mcu_fd_sc_mcu7t5v0__fillcap_16
X_370_ _642_/Q _370_/A2 _370_/Z VPWR VPWR VGND VGND gf180mcu_fd_sc_mcu7t5v0__xor2_2
XFILLER_26_597 VPWR VPWR VGND VGND gf180mcu_fd_sc_mcu7t5v0__fillcap_8
XTAP_TAPCELL_ROW_23_286 VPWR VGND gf180mcu_fd_sc_mcu7t5v0__filltie
XFILLER_5_479 VPWR VPWR VGND VGND gf180mcu_fd_sc_mcu7t5v0__fillcap_8
X_637_ _637_/D _638_/CLK _637_/Q VPWR VPWR VGND VGND gf180mcu_fd_sc_mcu7t5v0__dffq_1
XFILLER_36_317 VPWR VPWR VGND VGND gf180mcu_fd_sc_mcu7t5v0__fill_2
XFILLER_17_553 VPWR VPWR VGND VGND gf180mcu_fd_sc_mcu7t5v0__fill_2
X_568_ input5/Z _586_/B1 _595_/A1 VPWR VPWR VGND VGND gf180mcu_fd_sc_mcu7t5v0__nand2_1
X_499_ _645_/Q _523_/A3 _522_/A3 VPWR VPWR VGND VGND gf180mcu_fd_sc_mcu7t5v0__nand2_1
XTAP_TAPCELL_ROW_20_256 VPWR VGND gf180mcu_fd_sc_mcu7t5v0__filltie
XFILLER_18_317 VPWR VPWR VGND VGND gf180mcu_fd_sc_mcu7t5v0__fillcap_8
X_353_ _475_/B _648_/D _502_/B VPWR VPWR VGND VGND gf180mcu_fd_sc_mcu7t5v0__nor2_4
X_422_ _439_/A2 _449_/A3 _422_/B _422_/C _424_/A2 VPWR VPWR VGND VGND gf180mcu_fd_sc_mcu7t5v0__aoi211_4
XFILLER_5_276 VPWR VPWR VGND VGND gf180mcu_fd_sc_mcu7t5v0__fillcap_4
Xinput8 ui_in[6] input8/Z VPWR VPWR VGND VGND gf180mcu_fd_sc_mcu7t5v0__buf_1
XFILLER_37_604 VPWR VPWR VGND VGND gf180mcu_fd_sc_mcu7t5v0__fill_1
XTAP_TAPCELL_ROW_1_96 VPWR VGND gf180mcu_fd_sc_mcu7t5v0__filltie
XFILLER_27_136 VPWR VPWR VGND VGND gf180mcu_fd_sc_mcu7t5v0__fillcap_4
XTAP_TAPCELL_ROW_25_304 VPWR VGND gf180mcu_fd_sc_mcu7t5v0__filltie
XTAP_TAPCELL_ROW_33_370 VPWR VGND gf180mcu_fd_sc_mcu7t5v0__filltie
XFILLER_19_604 VPWR VPWR VGND VGND gf180mcu_fd_sc_mcu7t5v0__fill_1
X_405_ _471_/B _454_/C _406_/A4 VPWR VPWR VGND VGND gf180mcu_fd_sc_mcu7t5v0__nand2_1
X_336_ _366_/A2 _385_/A2 _403_/A3 VPWR VPWR VGND VGND gf180mcu_fd_sc_mcu7t5v0__nor2_4
XFILLER_28_434 VPWR VPWR VGND VGND gf180mcu_fd_sc_mcu7t5v0__fill_2
XFILLER_11_72 VPWR VPWR VGND VGND gf180mcu_fd_sc_mcu7t5v0__fillcap_64
XFILLER_19_489 VPWR VPWR VGND VGND gf180mcu_fd_sc_mcu7t5v0__fill_1
Xinput11 uio_in[1] _321_/I VPWR VPWR VGND VGND gf180mcu_fd_sc_mcu7t5v0__buf_1
X_319_ _657_/Q _549_/A1 VPWR VPWR VGND VGND gf180mcu_fd_sc_mcu7t5v0__clkinv_1
XTAP_TAPCELL_ROW_7_146 VPWR VGND gf180mcu_fd_sc_mcu7t5v0__filltie
X_670_ _670_/I uo_out[4] VPWR VPWR VGND VGND gf180mcu_fd_sc_mcu7t5v0__buf_8
XFILLER_11_142 VPWR VPWR VGND VGND gf180mcu_fd_sc_mcu7t5v0__fillcap_64
XFILLER_3_352 VPWR VPWR VGND VGND gf180mcu_fd_sc_mcu7t5v0__fillcap_64
Xtt_um_r2r_dac_digital_100 uio_oe[6] VPWR VPWR VGND VGND gf180mcu_fd_sc_mcu7t5v0__tieh
XTAP_TAPCELL_ROW_12_192 VPWR VGND gf180mcu_fd_sc_mcu7t5v0__filltie
XTAP_TAPCELL_ROW_4_127 VPWR VGND gf180mcu_fd_sc_mcu7t5v0__filltie
XFILLER_25_212 VPWR VPWR VGND VGND gf180mcu_fd_sc_mcu7t5v0__fillcap_32
X_653_ _653_/D _655_/CLK _653_/Q VPWR VPWR VGND VGND gf180mcu_fd_sc_mcu7t5v0__dffq_4
X_584_ input9/Z _586_/B1 _603_/A1 VPWR VPWR VGND VGND gf180mcu_fd_sc_mcu7t5v0__nand2_1
Xfanout19 _516_/C _645_/D VPWR VPWR VGND VGND gf180mcu_fd_sc_mcu7t5v0__buf_16
XFILLER_26_543 VPWR VPWR VGND VGND gf180mcu_fd_sc_mcu7t5v0__fill_2
XTAP_TAPCELL_ROW_23_287 VPWR VGND gf180mcu_fd_sc_mcu7t5v0__filltie
X_567_ _567_/A1 _567_/A2 _603_/B _628_/D VPWR VPWR VGND VGND gf180mcu_fd_sc_mcu7t5v0__aoi21_2
X_636_ _636_/D _646_/CLK _636_/Q VPWR VPWR VGND VGND gf180mcu_fd_sc_mcu7t5v0__dffq_1
XFILLER_8_241 VPWR VPWR VGND VGND gf180mcu_fd_sc_mcu7t5v0__fillcap_4
XTAP_TAPCELL_ROW_14_210 VPWR VGND gf180mcu_fd_sc_mcu7t5v0__filltie
X_498_ _510_/A2 _498_/A2 _498_/Z VPWR VPWR VGND VGND gf180mcu_fd_sc_mcu7t5v0__and2_4
XTAP_TAPCELL_ROW_20_257 VPWR VGND gf180mcu_fd_sc_mcu7t5v0__filltie
XFILLER_31_590 VPWR VPWR VGND VGND gf180mcu_fd_sc_mcu7t5v0__fillcap_8
XFILLER_14_513 VPWR VPWR VGND VGND gf180mcu_fd_sc_mcu7t5v0__fillcap_4
X_421_ _421_/A1 _449_/A3 _421_/B _421_/C _424_/B VPWR VPWR VGND VGND gf180mcu_fd_sc_mcu7t5v0__oai211_4
XTAP_TAPCELL_ROW_28_324 VPWR VGND gf180mcu_fd_sc_mcu7t5v0__filltie
X_352_ _352_/I _648_/D VPWR VPWR VGND VGND gf180mcu_fd_sc_mcu7t5v0__inv_4
Xinput9 ui_in[7] input9/Z VPWR VPWR VGND VGND gf180mcu_fd_sc_mcu7t5v0__buf_1
XTAP_TAPCELL_ROW_1_97 VPWR VGND gf180mcu_fd_sc_mcu7t5v0__filltie
X_619_ _619_/D _656_/CLK _619_/Q VPWR VPWR VGND VGND gf180mcu_fd_sc_mcu7t5v0__dffq_1
XFILLER_9_594 VPWR VPWR VGND VGND gf180mcu_fd_sc_mcu7t5v0__fillcap_8
XFILLER_32_387 VPWR VPWR VGND VGND gf180mcu_fd_sc_mcu7t5v0__fill_2
XTAP_TAPCELL_ROW_25_305 VPWR VGND gf180mcu_fd_sc_mcu7t5v0__filltie
XFILLER_23_310 VPWR VPWR VGND VGND gf180mcu_fd_sc_mcu7t5v0__fill_2
XTAP_TAPCELL_ROW_33_371 VPWR VGND gf180mcu_fd_sc_mcu7t5v0__filltie
XFILLER_2_247 VPWR VPWR VGND VGND gf180mcu_fd_sc_mcu7t5v0__fillcap_64
X_404_ _400_/C _404_/A2 _399_/B _404_/A4 _423_/A2 VPWR VPWR VGND VGND gf180mcu_fd_sc_mcu7t5v0__nand4_2
X_335_ _644_/Q _382_/A1 _385_/A2 VPWR VPWR VGND VGND gf180mcu_fd_sc_mcu7t5v0__nand2_4
XFILLER_6_597 VPWR VPWR VGND VGND gf180mcu_fd_sc_mcu7t5v0__fillcap_8
XPHY_EDGE_ROW_10_Right_10 VPWR VGND gf180mcu_fd_sc_mcu7t5v0__endcap
XFILLER_24_107 VPWR VPWR VGND VGND gf180mcu_fd_sc_mcu7t5v0__fillcap_64
XTAP_TAPCELL_ROW_30_341 VPWR VGND gf180mcu_fd_sc_mcu7t5v0__filltie
Xmax_cap27 wire28/Z _474_/A1 VPWR VPWR VGND VGND gf180mcu_fd_sc_mcu7t5v0__buf_4
XFILLER_28_468 VPWR VPWR VGND VGND gf180mcu_fd_sc_mcu7t5v0__fill_1
XFILLER_3_556 VPWR VPWR VGND VGND gf180mcu_fd_sc_mcu7t5v0__fillcap_4
XFILLER_2_2 VPWR VPWR VGND VGND gf180mcu_fd_sc_mcu7t5v0__fillcap_32
XPHY_EDGE_ROW_26_Left_65 VPWR VGND gf180mcu_fd_sc_mcu7t5v0__endcap
Xinput12 uio_in[2] _330_/B VPWR VPWR VGND VGND gf180mcu_fd_sc_mcu7t5v0__buf_1
XPHY_EDGE_ROW_10_Left_49 VPWR VGND gf180mcu_fd_sc_mcu7t5v0__endcap
X_318_ _656_/Q _547_/A1 VPWR VPWR VGND VGND gf180mcu_fd_sc_mcu7t5v0__clkinv_1
XFILLER_35_2 VPWR VPWR VGND VGND gf180mcu_fd_sc_mcu7t5v0__fillcap_64
XFILLER_21_600 VPWR VPWR VGND VGND gf180mcu_fd_sc_mcu7t5v0__fillcap_4
XTAP_TAPCELL_ROW_7_147 VPWR VGND gf180mcu_fd_sc_mcu7t5v0__filltie
XFILLER_7_136 VPWR VPWR VGND VGND gf180mcu_fd_sc_mcu7t5v0__fillcap_4
XFILLER_19_276 VPWR VPWR VGND VGND gf180mcu_fd_sc_mcu7t5v0__fillcap_4
Xtt_um_r2r_dac_digital_101 uio_oe[7] VPWR VPWR VGND VGND gf180mcu_fd_sc_mcu7t5v0__tieh
XTAP_TAPCELL_ROW_12_193 VPWR VGND gf180mcu_fd_sc_mcu7t5v0__filltie
XTAP_TAPCELL_ROW_4_128 VPWR VGND gf180mcu_fd_sc_mcu7t5v0__filltie
XFILLER_25_268 VPWR VPWR VGND VGND gf180mcu_fd_sc_mcu7t5v0__fillcap_4
XFILLER_17_72 VPWR VPWR VGND VGND gf180mcu_fd_sc_mcu7t5v0__fillcap_64
X_652_ _652_/D _655_/CLK _652_/Q VPWR VPWR VGND VGND gf180mcu_fd_sc_mcu7t5v0__dffq_4
X_583_ _583_/A1 _583_/A2 _603_/B _632_/D VPWR VPWR VGND VGND gf180mcu_fd_sc_mcu7t5v0__aoi21_2
XPHY_EDGE_ROW_8_Right_8 VPWR VGND gf180mcu_fd_sc_mcu7t5v0__endcap
XFILLER_15_290 VPWR VPWR VGND VGND gf180mcu_fd_sc_mcu7t5v0__fillcap_4
XPHY_EDGE_ROW_13_Left_52 VPWR VGND gf180mcu_fd_sc_mcu7t5v0__endcap
XFILLER_21_260 VPWR VPWR VGND VGND gf180mcu_fd_sc_mcu7t5v0__fillcap_8
XFILLER_21_282 VPWR VPWR VGND VGND gf180mcu_fd_sc_mcu7t5v0__fillcap_4
XTAP_TAPCELL_ROW_23_288 VPWR VGND gf180mcu_fd_sc_mcu7t5v0__filltie
XFILLER_36_319 VPWR VPWR VGND VGND gf180mcu_fd_sc_mcu7t5v0__fill_1
XTAP_TAPCELL_ROW_14_211 VPWR VGND gf180mcu_fd_sc_mcu7t5v0__filltie
XFILLER_17_555 VPWR VPWR VGND VGND gf180mcu_fd_sc_mcu7t5v0__fill_1
X_566_ _620_/Q _585_/A2 _586_/B1 input4/Z _567_/A2 VPWR VPWR VGND VGND gf180mcu_fd_sc_mcu7t5v0__aoi22_1
X_635_ _635_/D _656_/CLK _635_/Q VPWR VPWR VGND VGND gf180mcu_fd_sc_mcu7t5v0__dffq_1
X_497_ _520_/B _497_/A2 _510_/A2 VPWR VPWR VGND VGND gf180mcu_fd_sc_mcu7t5v0__nor2_2
XTAP_TAPCELL_ROW_20_258 VPWR VGND gf180mcu_fd_sc_mcu7t5v0__filltie
XTAP_TAPCELL_ROW_28_325 VPWR VGND gf180mcu_fd_sc_mcu7t5v0__filltie
X_420_ _420_/A1 _520_/B _541_/B VPWR VPWR VGND VGND gf180mcu_fd_sc_mcu7t5v0__nand2_4
X_351_ _351_/A1 _351_/A2 _400_/C _352_/I VPWR VPWR VGND VGND gf180mcu_fd_sc_mcu7t5v0__nand3_4
XFILLER_5_212 VPWR VPWR VGND VGND gf180mcu_fd_sc_mcu7t5v0__fillcap_64
XTAP_TAPCELL_ROW_1_98 VPWR VGND gf180mcu_fd_sc_mcu7t5v0__filltie
X_549_ _549_/A1 _549_/A2 _549_/B _657_/D VPWR VPWR VGND VGND gf180mcu_fd_sc_mcu7t5v0__aoi21_1
X_618_ _618_/D _657_/CLK _618_/Q VPWR VPWR VGND VGND gf180mcu_fd_sc_mcu7t5v0__dffq_1
XFILLER_9_562 VPWR VPWR VGND VGND gf180mcu_fd_sc_mcu7t5v0__fillcap_32
XTAP_TAPCELL_ROW_25_306 VPWR VGND gf180mcu_fd_sc_mcu7t5v0__filltie
XTAP_TAPCELL_ROW_33_372 VPWR VGND gf180mcu_fd_sc_mcu7t5v0__filltie
XFILLER_14_322 VPWR VPWR VGND VGND gf180mcu_fd_sc_mcu7t5v0__fillcap_16
X_403_ _400_/B _559_/B _403_/A3 _403_/A4 _471_/A1 VPWR VPWR VGND VGND gf180mcu_fd_sc_mcu7t5v0__nor4_4
XFILLER_25_72 VPWR VPWR VGND VGND gf180mcu_fd_sc_mcu7t5v0__fillcap_64
XFILLER_26_171 VPWR VPWR VGND VGND gf180mcu_fd_sc_mcu7t5v0__fillcap_4
X_334_ _383_/B _383_/A2 _384_/A2 VPWR VPWR VGND VGND gf180mcu_fd_sc_mcu7t5v0__nor2_4
XFILLER_6_521 VPWR VPWR VGND VGND gf180mcu_fd_sc_mcu7t5v0__fillcap_4
XTAP_TAPCELL_ROW_30_342 VPWR VGND gf180mcu_fd_sc_mcu7t5v0__filltie
XTAP_TAPCELL_ROW_38_420 VPWR VGND gf180mcu_fd_sc_mcu7t5v0__filltie
XFILLER_28_436 VPWR VPWR VGND VGND gf180mcu_fd_sc_mcu7t5v0__fill_1
XFILLER_11_314 VPWR VPWR VGND VGND gf180mcu_fd_sc_mcu7t5v0__fill_1
Xmax_cap39 _458_/A1 _490_/A1 VPWR VPWR VGND VGND gf180mcu_fd_sc_mcu7t5v0__buf_8
XPHY_EDGE_ROW_1_Left_40 VPWR VGND gf180mcu_fd_sc_mcu7t5v0__endcap
XFILLER_19_436 VPWR VPWR VGND VGND gf180mcu_fd_sc_mcu7t5v0__fill_1
Xclone128 _356_/ZN _468_/C VPWR VPWR VGND VGND gf180mcu_fd_sc_mcu7t5v0__buf_1
X_317_ _653_/Q _610_/A1 VPWR VPWR VGND VGND gf180mcu_fd_sc_mcu7t5v0__clkinv_1
XFILLER_10_391 VPWR VPWR VGND VGND gf180mcu_fd_sc_mcu7t5v0__fill_1
XFILLER_28_2 VPWR VPWR VGND VGND gf180mcu_fd_sc_mcu7t5v0__fillcap_32
XFILLER_20_177 VPWR VPWR VGND VGND gf180mcu_fd_sc_mcu7t5v0__fillcap_64
XTAP_TAPCELL_ROW_7_148 VPWR VGND gf180mcu_fd_sc_mcu7t5v0__filltie
Xwire70 wire70/I wire70/Z VPWR VPWR VGND VGND gf180mcu_fd_sc_mcu7t5v0__buf_4
Xwire81 _629_/Q uio_out[3] VPWR VPWR VGND VGND gf180mcu_fd_sc_mcu7t5v0__buf_4
XFILLER_34_247 VPWR VPWR VGND VGND gf180mcu_fd_sc_mcu7t5v0__fillcap_4
XTAP_TAPCELL_ROW_12_194 VPWR VGND gf180mcu_fd_sc_mcu7t5v0__filltie
XFILLER_15_483 VPWR VPWR VGND VGND gf180mcu_fd_sc_mcu7t5v0__fill_1
XFILLER_4_107 VPWR VPWR VGND VGND gf180mcu_fd_sc_mcu7t5v0__fillcap_64
X_582_ _640_/Q _586_/A2 _582_/B1 input8/Z _583_/A2 VPWR VPWR VGND VGND gf180mcu_fd_sc_mcu7t5v0__aoi22_1
XFILLER_16_247 VPWR VPWR VGND VGND gf180mcu_fd_sc_mcu7t5v0__fillcap_16
X_651_ _651_/D _655_/CLK _651_/Q VPWR VPWR VGND VGND gf180mcu_fd_sc_mcu7t5v0__dffq_4
XFILLER_29_597 VPWR VPWR VGND VGND gf180mcu_fd_sc_mcu7t5v0__fillcap_8
XFILLER_31_206 VPWR VPWR VGND VGND gf180mcu_fd_sc_mcu7t5v0__fillcap_4
XFILLER_12_453 VPWR VPWR VGND VGND gf180mcu_fd_sc_mcu7t5v0__fill_2
XFILLER_33_72 VPWR VPWR VGND VGND gf180mcu_fd_sc_mcu7t5v0__fillcap_64
XTAP_TAPCELL_ROW_17_231 VPWR VGND gf180mcu_fd_sc_mcu7t5v0__filltie
XFILLER_13_206 VPWR VPWR VGND VGND gf180mcu_fd_sc_mcu7t5v0__fillcap_4
XFILLER_26_523 VPWR VPWR VGND VGND gf180mcu_fd_sc_mcu7t5v0__fill_2
XTAP_TAPCELL_ROW_23_289 VPWR VGND gf180mcu_fd_sc_mcu7t5v0__filltie
XFILLER_5_416 VPWR VPWR VGND VGND gf180mcu_fd_sc_mcu7t5v0__fillcap_4
X_634_ _634_/D _656_/CLK _634_/Q VPWR VPWR VGND VGND gf180mcu_fd_sc_mcu7t5v0__dffq_1
XTAP_TAPCELL_ROW_14_212 VPWR VGND gf180mcu_fd_sc_mcu7t5v0__filltie
X_565_ input4/Z _586_/B1 _593_/A1 VPWR VPWR VGND VGND gf180mcu_fd_sc_mcu7t5v0__nand2_1
X_496_ _421_/C _496_/A2 _496_/B1 _505_/C _515_/B _497_/A2 VPWR VPWR VGND VGND gf180mcu_fd_sc_mcu7t5v0__aoi221_4
XFILLER_10_2 VPWR VPWR VGND VGND gf180mcu_fd_sc_mcu7t5v0__fillcap_32
XTAP_TAPCELL_ROW_20_259 VPWR VGND gf180mcu_fd_sc_mcu7t5v0__filltie
XTAP_TAPCELL_ROW_36_392 VPWR VGND gf180mcu_fd_sc_mcu7t5v0__filltie
XTAP_TAPCELL_ROW_28_326 VPWR VGND gf180mcu_fd_sc_mcu7t5v0__filltie
X_350_ _350_/A1 _350_/A2 _350_/B _351_/A2 VPWR VPWR VGND VGND gf180mcu_fd_sc_mcu7t5v0__oai21_4
XTAP_TAPCELL_ROW_1_99 VPWR VGND gf180mcu_fd_sc_mcu7t5v0__filltie
XFILLER_17_331 VPWR VPWR VGND VGND gf180mcu_fd_sc_mcu7t5v0__fill_1
X_617_ _617_/A1 _617_/A2 _655_/D VPWR VPWR VGND VGND gf180mcu_fd_sc_mcu7t5v0__nor2_1
X_479_ _479_/A1 _646_/D _479_/A3 _479_/B1 _479_/B2 _480_/B1 VPWR VPWR VGND VGND gf180mcu_fd_sc_mcu7t5v0__oai32_4
XFILLER_20_518 VPWR VPWR VGND VGND gf180mcu_fd_sc_mcu7t5v0__fill_2
X_548_ _549_/A1 _549_/A2 _613_/B _549_/B VPWR VPWR VGND VGND gf180mcu_fd_sc_mcu7t5v0__oai21_1
XTAP_TAPCELL_ROW_33_373 VPWR VGND gf180mcu_fd_sc_mcu7t5v0__filltie
X_402_ wire55/Z _437_/A1 _443_/A3 _402_/B _406_/A1 VPWR VPWR VGND VGND gf180mcu_fd_sc_mcu7t5v0__oai31_1
X_333_ _383_/A1 _383_/A2 _378_/A4 VPWR VPWR VGND VGND gf180mcu_fd_sc_mcu7t5v0__nor2_4
XFILLER_1_282 VPWR VPWR VGND VGND gf180mcu_fd_sc_mcu7t5v0__fillcap_64
XFILLER_9_360 VPWR VPWR VGND VGND gf180mcu_fd_sc_mcu7t5v0__fill_2
XTAP_TAPCELL_ROW_30_343 VPWR VGND gf180mcu_fd_sc_mcu7t5v0__filltie
XTAP_TAPCELL_ROW_38_421 VPWR VGND gf180mcu_fd_sc_mcu7t5v0__filltie
XTAP_TAPCELL_ROW_38_410 VPWR VGND gf180mcu_fd_sc_mcu7t5v0__filltie
XFILLER_23_142 VPWR VPWR VGND VGND gf180mcu_fd_sc_mcu7t5v0__fillcap_64
Xclone118 _370_/A2 _366_/A2 VPWR VPWR VGND VGND gf180mcu_fd_sc_mcu7t5v0__buf_4
XFILLER_27_492 VPWR VPWR VGND VGND gf180mcu_fd_sc_mcu7t5v0__fill_2
X_316_ _642_/Q _369_/A1 VPWR VPWR VGND VGND gf180mcu_fd_sc_mcu7t5v0__inv_2
XFILLER_6_341 VPWR VPWR VGND VGND gf180mcu_fd_sc_mcu7t5v0__fillcap_4
XFILLER_37_212 VPWR VPWR VGND VGND gf180mcu_fd_sc_mcu7t5v0__fillcap_4
XFILLER_2_591 VPWR VPWR VGND VGND gf180mcu_fd_sc_mcu7t5v0__fillcap_4
XFILLER_20_101 VPWR VPWR VGND VGND gf180mcu_fd_sc_mcu7t5v0__fillcap_4
XTAP_TAPCELL_ROW_7_149 VPWR VGND gf180mcu_fd_sc_mcu7t5v0__filltie
XFILLER_19_212 VPWR VPWR VGND VGND gf180mcu_fd_sc_mcu7t5v0__fillcap_64
XFILLER_6_171 VPWR VPWR VGND VGND gf180mcu_fd_sc_mcu7t5v0__fillcap_4
XTAP_TAPCELL_ROW_12_195 VPWR VGND gf180mcu_fd_sc_mcu7t5v0__filltie
XFILLER_30_498 VPWR VPWR VGND VGND gf180mcu_fd_sc_mcu7t5v0__fill_1
XFILLER_38_598 VPWR VPWR VGND VGND gf180mcu_fd_sc_mcu7t5v0__fillcap_4
XFILLER_38_576 VPWR VPWR VGND VGND gf180mcu_fd_sc_mcu7t5v0__fill_2
X_650_ _650_/D _657_/CLK _650_/Q VPWR VPWR VGND VGND gf180mcu_fd_sc_mcu7t5v0__dffq_4
X_581_ _624_/Q _585_/A2 _585_/B1 _648_/Q _583_/A1 VPWR VPWR VGND VGND gf180mcu_fd_sc_mcu7t5v0__aoi22_1
XTAP_TAPCELL_ROW_17_232 VPWR VGND gf180mcu_fd_sc_mcu7t5v0__filltie
XFILLER_34_590 VPWR VPWR VGND VGND gf180mcu_fd_sc_mcu7t5v0__fillcap_4
X_633_ _633_/D _633_/CLK _633_/Q VPWR VPWR VGND VGND gf180mcu_fd_sc_mcu7t5v0__dffq_4
X_564_ _644_/Q _585_/B1 _586_/A2 _636_/Q _567_/A1 VPWR VPWR VGND VGND gf180mcu_fd_sc_mcu7t5v0__aoi22_1
XTAP_TAPCELL_ROW_14_213 VPWR VGND gf180mcu_fd_sc_mcu7t5v0__filltie
X_495_ _495_/A1 wire34/I wire25/I _495_/B _496_/B1 VPWR VPWR VGND VGND gf180mcu_fd_sc_mcu7t5v0__oai31_4
XFILLER_12_295 VPWR VPWR VGND VGND gf180mcu_fd_sc_mcu7t5v0__fillcap_4
XFILLER_5_66 VPWR VPWR VGND VGND gf180mcu_fd_sc_mcu7t5v0__fillcap_4
XTAP_TAPCELL_ROW_28_327 VPWR VGND gf180mcu_fd_sc_mcu7t5v0__filltie
XTAP_TAPCELL_ROW_36_393 VPWR VGND gf180mcu_fd_sc_mcu7t5v0__filltie
XFILLER_22_593 VPWR VPWR VGND VGND gf180mcu_fd_sc_mcu7t5v0__fill_2
XFILLER_1_486 VPWR VPWR VGND VGND gf180mcu_fd_sc_mcu7t5v0__fillcap_4
XFILLER_36_107 VPWR VPWR VGND VGND gf180mcu_fd_sc_mcu7t5v0__fillcap_64
X_616_ _613_/B _616_/A2 _617_/A2 VPWR VPWR VGND VGND gf180mcu_fd_sc_mcu7t5v0__nand2_1
X_547_ _547_/A1 _616_/A2 _547_/B _656_/D VPWR VPWR VGND VGND gf180mcu_fd_sc_mcu7t5v0__aoi21_1
X_478_ _478_/A1 _475_/B _505_/C _479_/B2 VPWR VPWR VGND VGND gf180mcu_fd_sc_mcu7t5v0__oai21_4
XFILLER_11_508 VPWR VPWR VGND VGND gf180mcu_fd_sc_mcu7t5v0__fillcap_32
XTAP_TAPCELL_ROW_33_374 VPWR VGND gf180mcu_fd_sc_mcu7t5v0__filltie
X_401_ wire55/Z _643_/D _477_/B VPWR VPWR VGND VGND gf180mcu_fd_sc_mcu7t5v0__nor2_4
XFILLER_18_107 VPWR VPWR VGND VGND gf180mcu_fd_sc_mcu7t5v0__fillcap_64
X_332_ _643_/Q _642_/Q _383_/A2 VPWR VPWR VGND VGND gf180mcu_fd_sc_mcu7t5v0__nand2_2
XFILLER_2_34 VPWR VPWR VGND VGND gf180mcu_fd_sc_mcu7t5v0__fill_1
Xtt_um_r2r_dac_digital uio_oe[0] VPWR VPWR VGND VGND gf180mcu_fd_sc_mcu7t5v0__tieh
XTAP_TAPCELL_ROW_30_344 VPWR VGND gf180mcu_fd_sc_mcu7t5v0__filltie
XTAP_TAPCELL_ROW_38_422 VPWR VGND gf180mcu_fd_sc_mcu7t5v0__filltie
XTAP_TAPCELL_ROW_38_411 VPWR VGND gf180mcu_fd_sc_mcu7t5v0__filltie
X_315_ _643_/Q _364_/B VPWR VPWR VGND VGND gf180mcu_fd_sc_mcu7t5v0__inv_2
Xwire83 _628_/Q uio_out[2] VPWR VPWR VGND VGND gf180mcu_fd_sc_mcu7t5v0__buf_8
XFILLER_0_2 VPWR VPWR VGND VGND gf180mcu_fd_sc_mcu7t5v0__fillcap_32
Xclkbuf_3_4__f_clk clkbuf_0_clk/Z _657_/CLK VPWR VPWR VGND VGND gf180mcu_fd_sc_mcu7t5v0__clkbuf_8
XTAP_TAPCELL_ROW_12_196 VPWR VGND gf180mcu_fd_sc_mcu7t5v0__filltie
XFILLER_33_2 VPWR VPWR VGND VGND gf180mcu_fd_sc_mcu7t5v0__fillcap_64
XFILLER_21_422 VPWR VPWR VGND VGND gf180mcu_fd_sc_mcu7t5v0__fill_2
XFILLER_21_488 VPWR VPWR VGND VGND gf180mcu_fd_sc_mcu7t5v0__fill_2
XFILLER_33_282 VPWR VPWR VGND VGND gf180mcu_fd_sc_mcu7t5v0__fill_1
X_580_ input8/Z _582_/B1 _601_/A1 VPWR VPWR VGND VGND gf180mcu_fd_sc_mcu7t5v0__nand2_1
XFILLER_3_142 VPWR VPWR VGND VGND gf180mcu_fd_sc_mcu7t5v0__fillcap_64
XTAP_TAPCELL_ROW_17_233 VPWR VGND gf180mcu_fd_sc_mcu7t5v0__filltie
XFILLER_15_282 VPWR VPWR VGND VGND gf180mcu_fd_sc_mcu7t5v0__fillcap_8
XFILLER_30_241 VPWR VPWR VGND VGND gf180mcu_fd_sc_mcu7t5v0__fillcap_4
XFILLER_30_263 VPWR VPWR VGND VGND gf180mcu_fd_sc_mcu7t5v0__fillcap_4
XFILLER_7_492 VPWR VPWR VGND VGND gf180mcu_fd_sc_mcu7t5v0__fillcap_64
XPHY_EDGE_ROW_17_Right_17 VPWR VGND gf180mcu_fd_sc_mcu7t5v0__endcap
XFILLER_1_602 VPWR VPWR VGND VGND gf180mcu_fd_sc_mcu7t5v0__fill_2
XPHY_EDGE_ROW_26_Right_26 VPWR VGND gf180mcu_fd_sc_mcu7t5v0__endcap
X_563_ _563_/A1 _563_/A2 _601_/B _627_/D VPWR VPWR VGND VGND gf180mcu_fd_sc_mcu7t5v0__aoi21_2
X_632_ _632_/D _633_/CLK _632_/Q VPWR VPWR VGND VGND gf180mcu_fd_sc_mcu7t5v0__dffq_4
XPHY_EDGE_ROW_35_Right_35 VPWR VGND gf180mcu_fd_sc_mcu7t5v0__endcap
XFILLER_12_241 VPWR VPWR VGND VGND gf180mcu_fd_sc_mcu7t5v0__fillcap_4
X_494_ wire46/Z _407_/B _494_/B _495_/B VPWR VPWR VGND VGND gf180mcu_fd_sc_mcu7t5v0__oai21_4
XFILLER_4_451 VPWR VPWR VGND VGND gf180mcu_fd_sc_mcu7t5v0__fillcap_4
XTAP_TAPCELL_ROW_22_280 VPWR VGND gf180mcu_fd_sc_mcu7t5v0__filltie
XPHY_EDGE_ROW_17_Left_56 VPWR VGND gf180mcu_fd_sc_mcu7t5v0__endcap
XTAP_TAPCELL_ROW_28_328 VPWR VGND gf180mcu_fd_sc_mcu7t5v0__filltie
XTAP_TAPCELL_ROW_36_394 VPWR VGND gf180mcu_fd_sc_mcu7t5v0__filltie
XFILLER_14_517 VPWR VPWR VGND VGND gf180mcu_fd_sc_mcu7t5v0__fill_2
X_615_ _654_/Q _325_/Z _655_/Q _617_/A1 VPWR VPWR VGND VGND gf180mcu_fd_sc_mcu7t5v0__aoi21_1
X_546_ _613_/B _549_/A2 _547_/B VPWR VPWR VGND VGND gf180mcu_fd_sc_mcu7t5v0__nand2_1
X_477_ _477_/A1 _477_/A2 _477_/B _515_/B _479_/B1 VPWR VPWR VGND VGND gf180mcu_fd_sc_mcu7t5v0__aoi211_4
XFILLER_13_594 VPWR VPWR VGND VGND gf180mcu_fd_sc_mcu7t5v0__fillcap_8
X_400_ _403_/A3 _396_/B _400_/B _400_/C _423_/A1 VPWR VPWR VGND VGND gf180mcu_fd_sc_mcu7t5v0__oai211_2
X_331_ _364_/B _369_/A1 _382_/A1 VPWR VPWR VGND VGND gf180mcu_fd_sc_mcu7t5v0__nor2_4
Xrebuffer150 _345_/ZN _544_/B VPWR VPWR VGND VGND gf180mcu_fd_sc_mcu7t5v0__buf_8
XFILLER_10_597 VPWR VPWR VGND VGND gf180mcu_fd_sc_mcu7t5v0__fillcap_8
XFILLER_20_317 VPWR VPWR VGND VGND gf180mcu_fd_sc_mcu7t5v0__fill_1
X_529_ _529_/A1 _514_/Z _529_/B _529_/C _530_/A2 VPWR VPWR VGND VGND gf180mcu_fd_sc_mcu7t5v0__oai211_1
XFILLER_32_177 VPWR VPWR VGND VGND gf180mcu_fd_sc_mcu7t5v0__fillcap_64
XTAP_TAPCELL_ROW_30_345 VPWR VGND gf180mcu_fd_sc_mcu7t5v0__filltie
XFILLER_28_406 VPWR VPWR VGND VGND gf180mcu_fd_sc_mcu7t5v0__fill_1
XTAP_TAPCELL_ROW_38_423 VPWR VGND gf180mcu_fd_sc_mcu7t5v0__filltie
XTAP_TAPCELL_ROW_38_412 VPWR VGND gf180mcu_fd_sc_mcu7t5v0__filltie
XFILLER_11_66 VPWR VPWR VGND VGND gf180mcu_fd_sc_mcu7t5v0__fillcap_4
XFILLER_14_177 VPWR VPWR VGND VGND gf180mcu_fd_sc_mcu7t5v0__fillcap_64
XFILLER_27_494 VPWR VPWR VGND VGND gf180mcu_fd_sc_mcu7t5v0__fill_1
X_314_ _644_/Q _383_/B VPWR VPWR VGND VGND gf180mcu_fd_sc_mcu7t5v0__inv_2
XTAP_TAPCELL_ROW_9_170 VPWR VGND gf180mcu_fd_sc_mcu7t5v0__filltie
XFILLER_21_604 VPWR VPWR VGND VGND gf180mcu_fd_sc_mcu7t5v0__fill_1
XFILLER_28_247 VPWR VPWR VGND VGND gf180mcu_fd_sc_mcu7t5v0__fillcap_16
Xwire73 _633_/Q uio_out[7] VPWR VPWR VGND VGND gf180mcu_fd_sc_mcu7t5v0__buf_8
XPHY_EDGE_ROW_5_Left_44 VPWR VGND gf180mcu_fd_sc_mcu7t5v0__endcap
XFILLER_11_136 VPWR VPWR VGND VGND gf180mcu_fd_sc_mcu7t5v0__fillcap_4
XTAP_TAPCELL_ROW_6_140 VPWR VGND gf180mcu_fd_sc_mcu7t5v0__filltie
XFILLER_3_346 VPWR VPWR VGND VGND gf180mcu_fd_sc_mcu7t5v0__fillcap_4
XFILLER_8_34 VPWR VPWR VGND VGND gf180mcu_fd_sc_mcu7t5v0__fill_1
XFILLER_30_467 VPWR VPWR VGND VGND gf180mcu_fd_sc_mcu7t5v0__fill_2
XFILLER_26_2 VPWR VPWR VGND VGND gf180mcu_fd_sc_mcu7t5v0__fillcap_32
XFILLER_25_206 VPWR VPWR VGND VGND gf180mcu_fd_sc_mcu7t5v0__fillcap_4
XTAP_TAPCELL_ROW_17_234 VPWR VGND gf180mcu_fd_sc_mcu7t5v0__filltie
XFILLER_35_559 VPWR VPWR VGND VGND gf180mcu_fd_sc_mcu7t5v0__fill_1
XFILLER_15_294 VPWR VPWR VGND VGND gf180mcu_fd_sc_mcu7t5v0__fill_1
XFILLER_21_286 VPWR VPWR VGND VGND gf180mcu_fd_sc_mcu7t5v0__fill_2
X_631_ _631_/D _645_/CLK _631_/Q VPWR VPWR VGND VGND gf180mcu_fd_sc_mcu7t5v0__dffq_4
X_562_ _635_/Q _586_/A2 _582_/B1 input3/Z _563_/A2 VPWR VPWR VGND VGND gf180mcu_fd_sc_mcu7t5v0__aoi22_1
X_493_ _493_/A1 _493_/A2 _515_/B _498_/A2 VPWR VPWR VGND VGND gf180mcu_fd_sc_mcu7t5v0__oai21_4
XTAP_TAPCELL_ROW_22_281 VPWR VGND gf180mcu_fd_sc_mcu7t5v0__filltie
XFILLER_23_518 VPWR VPWR VGND VGND gf180mcu_fd_sc_mcu7t5v0__fillcap_4
XFILLER_38_172 VPWR VPWR VGND VGND gf180mcu_fd_sc_mcu7t5v0__fillcap_32
XFILLER_26_312 VPWR VPWR VGND VGND gf180mcu_fd_sc_mcu7t5v0__fill_2
XTAP_TAPCELL_ROW_28_329 VPWR VGND gf180mcu_fd_sc_mcu7t5v0__filltie
XTAP_TAPCELL_ROW_36_395 VPWR VGND gf180mcu_fd_sc_mcu7t5v0__filltie
XFILLER_1_422 VPWR VPWR VGND VGND gf180mcu_fd_sc_mcu7t5v0__fillcap_64
XPHY_EDGE_ROW_34_Left_73 VPWR VGND gf180mcu_fd_sc_mcu7t5v0__endcap
X_476_ _476_/A1 _476_/A2 _515_/B _479_/A3 VPWR VPWR VGND VGND gf180mcu_fd_sc_mcu7t5v0__aoi21_2
XFILLER_13_562 VPWR VPWR VGND VGND gf180mcu_fd_sc_mcu7t5v0__fillcap_32
X_614_ _654_/Q _325_/Z _614_/B _654_/D VPWR VPWR VGND VGND gf180mcu_fd_sc_mcu7t5v0__aoi21_1
X_545_ _550_/B _544_/B _545_/S _624_/D VPWR VPWR VGND VGND gf180mcu_fd_sc_mcu7t5v0__mux2_2
XFILLER_35_142 VPWR VPWR VGND VGND gf180mcu_fd_sc_mcu7t5v0__fillcap_64
X_330_ _549_/A1 _330_/A2 _330_/B wire70/I VPWR VPWR VGND VGND gf180mcu_fd_sc_mcu7t5v0__oai21_4
XFILLER_17_142 VPWR VPWR VGND VGND gf180mcu_fd_sc_mcu7t5v0__fillcap_64
XFILLER_9_352 VPWR VPWR VGND VGND gf180mcu_fd_sc_mcu7t5v0__fillcap_8
X_459_ _645_/D wire25/Z _529_/A1 VPWR VPWR VGND VGND gf180mcu_fd_sc_mcu7t5v0__nor2_4
X_528_ _528_/A1 _531_/A2 _649_/D _531_/B VPWR VPWR VGND VGND gf180mcu_fd_sc_mcu7t5v0__oai21_1
XTAP_TAPCELL_ROW_30_346 VPWR VGND gf180mcu_fd_sc_mcu7t5v0__filltie
XFILLER_32_101 VPWR VPWR VGND VGND gf180mcu_fd_sc_mcu7t5v0__fillcap_4
XTAP_TAPCELL_ROW_38_424 VPWR VGND gf180mcu_fd_sc_mcu7t5v0__filltie
XTAP_TAPCELL_ROW_38_413 VPWR VGND gf180mcu_fd_sc_mcu7t5v0__filltie
XFILLER_15_602 VPWR VPWR VGND VGND gf180mcu_fd_sc_mcu7t5v0__fill_2
X_313_ _645_/Q _358_/B VPWR VPWR VGND VGND gf180mcu_fd_sc_mcu7t5v0__clkinv_1
XFILLER_14_101 VPWR VPWR VGND VGND gf180mcu_fd_sc_mcu7t5v0__fillcap_4
XFILLER_6_333 VPWR VPWR VGND VGND gf180mcu_fd_sc_mcu7t5v0__fillcap_8
XFILLER_6_311 VPWR VPWR VGND VGND gf180mcu_fd_sc_mcu7t5v0__fillcap_4
XPHY_EDGE_ROW_21_Left_60 VPWR VGND gf180mcu_fd_sc_mcu7t5v0__endcap
Xwire85 _627_/Q uio_out[1] VPWR VPWR VGND VGND gf180mcu_fd_sc_mcu7t5v0__buf_8
XTAP_TAPCELL_ROW_6_141 VPWR VGND gf180mcu_fd_sc_mcu7t5v0__filltie
XFILLER_19_2 VPWR VPWR VGND VGND gf180mcu_fd_sc_mcu7t5v0__fillcap_64
XFILLER_17_66 VPWR VPWR VGND VGND gf180mcu_fd_sc_mcu7t5v0__fillcap_4
XTAP_TAPCELL_ROW_17_235 VPWR VGND gf180mcu_fd_sc_mcu7t5v0__filltie
XPHY_EDGE_ROW_3_Right_3 VPWR VGND gf180mcu_fd_sc_mcu7t5v0__endcap
XFILLER_34_582 VPWR VPWR VGND VGND gf180mcu_fd_sc_mcu7t5v0__fillcap_8
XFILLER_1_604 VPWR VPWR VGND VGND gf180mcu_fd_sc_mcu7t5v0__fill_1
X_630_ _630_/D _645_/CLK _630_/Q VPWR VPWR VGND VGND gf180mcu_fd_sc_mcu7t5v0__dffq_4
X_492_ _488_/C _491_/Z _493_/A2 VPWR VPWR VGND VGND gf180mcu_fd_sc_mcu7t5v0__nor2_2
XTAP_TAPCELL_ROW_14_205 VPWR VGND gf180mcu_fd_sc_mcu7t5v0__filltie
X_561_ _619_/Q _585_/A2 _585_/B1 _643_/Q _563_/A1 VPWR VPWR VGND VGND gf180mcu_fd_sc_mcu7t5v0__aoi22_1
XFILLER_8_247 VPWR VPWR VGND VGND gf180mcu_fd_sc_mcu7t5v0__fillcap_64
XFILLER_16_593 VPWR VPWR VGND VGND gf180mcu_fd_sc_mcu7t5v0__fill_2
XFILLER_31_574 VPWR VPWR VGND VGND gf180mcu_fd_sc_mcu7t5v0__fillcap_16
XTAP_TAPCELL_ROW_36_396 VPWR VGND gf180mcu_fd_sc_mcu7t5v0__filltie
XFILLER_5_206 VPWR VPWR VGND VGND gf180mcu_fd_sc_mcu7t5v0__fillcap_4
XFILLER_14_34 VPWR VPWR VGND VGND gf180mcu_fd_sc_mcu7t5v0__fill_1
X_613_ _654_/Q _325_/Z _613_/B _614_/B VPWR VPWR VGND VGND gf180mcu_fd_sc_mcu7t5v0__oai21_1
X_475_ _475_/A1 _475_/A2 _475_/B _479_/A1 VPWR VPWR VGND VGND gf180mcu_fd_sc_mcu7t5v0__aoi21_2
X_544_ wire34/I _544_/A2 _544_/B _550_/B VPWR VPWR VGND VGND gf180mcu_fd_sc_mcu7t5v0__aoi21_4
XFILLER_9_556 VPWR VPWR VGND VGND gf180mcu_fd_sc_mcu7t5v0__fillcap_4
XFILLER_14_338 VPWR VPWR VGND VGND gf180mcu_fd_sc_mcu7t5v0__fill_2
XFILLER_25_66 VPWR VPWR VGND VGND gf180mcu_fd_sc_mcu7t5v0__fillcap_4
XFILLER_10_522 VPWR VPWR VGND VGND gf180mcu_fd_sc_mcu7t5v0__fill_2
Xrebuffer163 wire67/Z _367_/A2 VPWR VPWR VGND VGND gf180mcu_fd_sc_mcu7t5v0__buf_8
XFILLER_2_37 VPWR VPWR VGND VGND gf180mcu_fd_sc_mcu7t5v0__fillcap_64
XFILLER_33_603 VPWR VPWR VGND VGND gf180mcu_fd_sc_mcu7t5v0__fill_2
X_527_ _530_/A1 _527_/A2 _648_/D _528_/A1 VPWR VPWR VGND VGND gf180mcu_fd_sc_mcu7t5v0__aoi21_1
X_458_ _458_/A1 _478_/A1 _645_/D _463_/A1 VPWR VPWR VGND VGND gf180mcu_fd_sc_mcu7t5v0__oai21_2
X_389_ _414_/C _388_/Z _646_/D _481_/B VPWR VPWR VGND VGND gf180mcu_fd_sc_mcu7t5v0__oai21_4
XTAP_TAPCELL_ROW_30_347 VPWR VGND gf180mcu_fd_sc_mcu7t5v0__filltie
XTAP_TAPCELL_ROW_38_425 VPWR VGND gf180mcu_fd_sc_mcu7t5v0__filltie
XTAP_TAPCELL_ROW_38_414 VPWR VGND gf180mcu_fd_sc_mcu7t5v0__filltie
XFILLER_36_452 VPWR VPWR VGND VGND gf180mcu_fd_sc_mcu7t5v0__fill_2
X_312_ _646_/Q _355_/B VPWR VPWR VGND VGND gf180mcu_fd_sc_mcu7t5v0__clkinv_1
XFILLER_10_374 VPWR VPWR VGND VGND gf180mcu_fd_sc_mcu7t5v0__fill_2
XFILLER_37_216 VPWR VPWR VGND VGND gf180mcu_fd_sc_mcu7t5v0__fill_2
Xwire75 _632_/Q uio_out[6] VPWR VPWR VGND VGND gf180mcu_fd_sc_mcu7t5v0__buf_8
XFILLER_22_34 VPWR VPWR VGND VGND gf180mcu_fd_sc_mcu7t5v0__fill_1
XTAP_TAPCELL_ROW_6_142 VPWR VGND gf180mcu_fd_sc_mcu7t5v0__filltie
XFILLER_27_260 VPWR VPWR VGND VGND gf180mcu_fd_sc_mcu7t5v0__fillcap_4
XFILLER_27_282 VPWR VPWR VGND VGND gf180mcu_fd_sc_mcu7t5v0__fill_2
XFILLER_10_171 VPWR VPWR VGND VGND gf180mcu_fd_sc_mcu7t5v0__fillcap_4
XTAP_TAPCELL_ROW_12_188 VPWR VGND gf180mcu_fd_sc_mcu7t5v0__filltie
XFILLER_2_381 VPWR VPWR VGND VGND gf180mcu_fd_sc_mcu7t5v0__fillcap_4
XTAP_TAPCELL_ROW_3_112 VPWR VGND gf180mcu_fd_sc_mcu7t5v0__filltie
XFILLER_24_241 VPWR VPWR VGND VGND gf180mcu_fd_sc_mcu7t5v0__fillcap_4
XFILLER_24_263 VPWR VPWR VGND VGND gf180mcu_fd_sc_mcu7t5v0__fill_1
XFILLER_29_558 VPWR VPWR VGND VGND gf180mcu_fd_sc_mcu7t5v0__fill_2
XFILLER_33_66 VPWR VPWR VGND VGND gf180mcu_fd_sc_mcu7t5v0__fillcap_4
XTAP_TAPCELL_ROW_17_236 VPWR VGND gf180mcu_fd_sc_mcu7t5v0__filltie
XFILLER_31_2 VPWR VPWR VGND VGND gf180mcu_fd_sc_mcu7t5v0__fillcap_64
XFILLER_0_70 VPWR VPWR VGND VGND gf180mcu_fd_sc_mcu7t5v0__fillcap_32
XFILLER_21_244 VPWR VPWR VGND VGND gf180mcu_fd_sc_mcu7t5v0__fillcap_16
XFILLER_34_594 VPWR VPWR VGND VGND gf180mcu_fd_sc_mcu7t5v0__fill_1
XFILLER_0_104 VPWR VPWR VGND VGND gf180mcu_fd_sc_mcu7t5v0__fillcap_32
X_560_ input3/Z _582_/B1 _591_/A1 VPWR VPWR VGND VGND gf180mcu_fd_sc_mcu7t5v0__nand2_1
XTAP_TAPCELL_ROW_14_206 VPWR VGND gf180mcu_fd_sc_mcu7t5v0__filltie
X_491_ _507_/A2 _506_/B _491_/Z VPWR VPWR VGND VGND gf180mcu_fd_sc_mcu7t5v0__xor2_1
XFILLER_12_299 VPWR VPWR VGND VGND gf180mcu_fd_sc_mcu7t5v0__fill_1
XPHY_EDGE_ROW_13_Right_13 VPWR VGND gf180mcu_fd_sc_mcu7t5v0__endcap
XPHY_EDGE_ROW_22_Right_22 VPWR VGND gf180mcu_fd_sc_mcu7t5v0__endcap
XFILLER_38_130 VPWR VPWR VGND VGND gf180mcu_fd_sc_mcu7t5v0__fill_1
XPHY_EDGE_ROW_31_Right_31 VPWR VGND gf180mcu_fd_sc_mcu7t5v0__endcap
XTAP_TAPCELL_ROW_36_397 VPWR VGND gf180mcu_fd_sc_mcu7t5v0__filltie
XFILLER_26_314 VPWR VPWR VGND VGND gf180mcu_fd_sc_mcu7t5v0__fill_1
XFILLER_22_597 VPWR VPWR VGND VGND gf180mcu_fd_sc_mcu7t5v0__fillcap_8
XFILLER_30_34 VPWR VPWR VGND VGND gf180mcu_fd_sc_mcu7t5v0__fill_1
XFILLER_17_325 VPWR VPWR VGND VGND gf180mcu_fd_sc_mcu7t5v0__fillcap_4
X_612_ _612_/A1 _612_/A2 _653_/D VPWR VPWR VGND VGND gf180mcu_fd_sc_mcu7t5v0__and2_1
XTAP_TAPCELL_ROW_27_320 VPWR VGND gf180mcu_fd_sc_mcu7t5v0__filltie
X_543_ _484_/B _543_/A2 _543_/B _545_/S VPWR VPWR VGND VGND gf180mcu_fd_sc_mcu7t5v0__aoi21_4
XFILLER_13_553 VPWR VPWR VGND VGND gf180mcu_fd_sc_mcu7t5v0__fillcap_4
X_474_ _474_/A1 _474_/A2 wire34/Z _645_/D _475_/A1 VPWR VPWR VGND VGND gf180mcu_fd_sc_mcu7t5v0__oai31_4
XFILLER_32_317 VPWR VPWR VGND VGND gf180mcu_fd_sc_mcu7t5v0__fill_1
XTAP_TAPCELL_ROW_33_367 VPWR VGND gf180mcu_fd_sc_mcu7t5v0__filltie
XFILLER_14_317 VPWR VPWR VGND VGND gf180mcu_fd_sc_mcu7t5v0__fill_1
XFILLER_26_177 VPWR VPWR VGND VGND gf180mcu_fd_sc_mcu7t5v0__fillcap_64
XFILLER_9_2 VPWR VPWR VGND VGND gf180mcu_fd_sc_mcu7t5v0__fillcap_64
XFILLER_6_527 VPWR VPWR VGND VGND gf180mcu_fd_sc_mcu7t5v0__fillcap_64
Xrebuffer120 max_cap41/I _439_/A2 VPWR VPWR VGND VGND gf180mcu_fd_sc_mcu7t5v0__buf_8
Xrebuffer131 wire70/I rebuffer131/Z VPWR VPWR VGND VGND gf180mcu_fd_sc_mcu7t5v0__clkbuf_8
Xrebuffer142 _349_/I rebuffer142/Z VPWR VPWR VGND VGND gf180mcu_fd_sc_mcu7t5v0__buf_8
XFILLER_1_276 VPWR VPWR VGND VGND gf180mcu_fd_sc_mcu7t5v0__fillcap_4
X_526_ _532_/C _526_/A2 _529_/B _529_/C _527_/A2 VPWR VPWR VGND VGND gf180mcu_fd_sc_mcu7t5v0__oai211_1
XFILLER_9_398 VPWR VPWR VGND VGND gf180mcu_fd_sc_mcu7t5v0__fillcap_4
X_457_ _520_/B _457_/A2 _457_/A3 _455_/Z _457_/B2 _470_/A2 VPWR VPWR VGND VGND gf180mcu_fd_sc_mcu7t5v0__oai32_4
X_388_ _449_/A3 _421_/A1 _388_/Z VPWR VPWR VGND VGND gf180mcu_fd_sc_mcu7t5v0__xor2_2
XTAP_TAPCELL_ROW_30_348 VPWR VGND gf180mcu_fd_sc_mcu7t5v0__filltie
XTAP_TAPCELL_ROW_38_415 VPWR VGND gf180mcu_fd_sc_mcu7t5v0__filltie
XFILLER_23_136 VPWR VPWR VGND VGND gf180mcu_fd_sc_mcu7t5v0__fillcap_4
XFILLER_15_604 VPWR VPWR VGND VGND gf180mcu_fd_sc_mcu7t5v0__fill_1
X_311_ _647_/Q _350_/A1 VPWR VPWR VGND VGND gf180mcu_fd_sc_mcu7t5v0__clkinv_1
XFILLER_37_206 VPWR VPWR VGND VGND gf180mcu_fd_sc_mcu7t5v0__fillcap_4
X_509_ _509_/A1 _508_/Z _541_/B _510_/C VPWR VPWR VGND VGND gf180mcu_fd_sc_mcu7t5v0__aoi21_2
Xwire87 _626_/Q uio_out[0] VPWR VPWR VGND VGND gf180mcu_fd_sc_mcu7t5v0__buf_8
XTAP_TAPCELL_ROW_6_143 VPWR VGND gf180mcu_fd_sc_mcu7t5v0__filltie
XFILLER_19_206 VPWR VPWR VGND VGND gf180mcu_fd_sc_mcu7t5v0__fillcap_4
XFILLER_8_37 VPWR VPWR VGND VGND gf180mcu_fd_sc_mcu7t5v0__fillcap_64
XTAP_TAPCELL_ROW_12_189 VPWR VGND gf180mcu_fd_sc_mcu7t5v0__filltie
XFILLER_0_308 VPWR VPWR VGND VGND gf180mcu_fd_sc_mcu7t5v0__fillcap_32
XTAP_TAPCELL_ROW_3_113 VPWR VGND gf180mcu_fd_sc_mcu7t5v0__filltie
XPHY_EDGE_ROW_9_Left_48 VPWR VGND gf180mcu_fd_sc_mcu7t5v0__endcap
XTAP_TAPCELL_ROW_17_237 VPWR VGND gf180mcu_fd_sc_mcu7t5v0__filltie
XFILLER_30_267 VPWR VPWR VGND VGND gf180mcu_fd_sc_mcu7t5v0__fill_1
XFILLER_24_2 VPWR VPWR VGND VGND gf180mcu_fd_sc_mcu7t5v0__fillcap_32
XFILLER_19_592 VPWR VPWR VGND VGND gf180mcu_fd_sc_mcu7t5v0__fillcap_8
XFILLER_21_212 VPWR VPWR VGND VGND gf180mcu_fd_sc_mcu7t5v0__fillcap_32
XFILLER_0_138 VPWR VPWR VGND VGND gf180mcu_fd_sc_mcu7t5v0__fillcap_32
XFILLER_28_34 VPWR VPWR VGND VGND gf180mcu_fd_sc_mcu7t5v0__fill_1
XTAP_TAPCELL_ROW_14_207 VPWR VGND gf180mcu_fd_sc_mcu7t5v0__filltie
X_490_ _490_/A1 wire46/Z _523_/A3 _490_/B _507_/A2 VPWR VPWR VGND VGND gf180mcu_fd_sc_mcu7t5v0__oai31_4
XTAP_TAPCELL_ROW_22_273 VPWR VGND gf180mcu_fd_sc_mcu7t5v0__filltie
XFILLER_31_598 VPWR VPWR VGND VGND gf180mcu_fd_sc_mcu7t5v0__fillcap_4
XFILLER_7_282 VPWR VPWR VGND VGND gf180mcu_fd_sc_mcu7t5v0__fillcap_64
XFILLER_38_164 VPWR VPWR VGND VGND gf180mcu_fd_sc_mcu7t5v0__fillcap_4
XFILLER_38_142 VPWR VPWR VGND VGND gf180mcu_fd_sc_mcu7t5v0__fill_2
XTAP_TAPCELL_ROW_36_398 VPWR VGND gf180mcu_fd_sc_mcu7t5v0__filltie
X_473_ _473_/A1 _473_/A2 _473_/B _480_/A2 VPWR VPWR VGND VGND gf180mcu_fd_sc_mcu7t5v0__oai21_1
X_611_ _559_/B _325_/Z _612_/A2 VPWR VPWR VGND VGND gf180mcu_fd_sc_mcu7t5v0__nor2_1
X_542_ _649_/D _542_/A2 _542_/A3 _542_/B _623_/D VPWR VPWR VGND VGND gf180mcu_fd_sc_mcu7t5v0__oai31_1
XTAP_TAPCELL_ROW_27_321 VPWR VGND gf180mcu_fd_sc_mcu7t5v0__filltie
XFILLER_29_142 VPWR VPWR VGND VGND gf180mcu_fd_sc_mcu7t5v0__fillcap_64
XFILLER_4_241 VPWR VPWR VGND VGND gf180mcu_fd_sc_mcu7t5v0__fillcap_4
XTAP_TAPCELL_ROW_33_368 VPWR VGND gf180mcu_fd_sc_mcu7t5v0__filltie
XFILLER_8_591 VPWR VPWR VGND VGND gf180mcu_fd_sc_mcu7t5v0__fillcap_4
XFILLER_26_101 VPWR VPWR VGND VGND gf180mcu_fd_sc_mcu7t5v0__fillcap_4
XPHY_EDGE_ROW_38_Left_77 VPWR VGND gf180mcu_fd_sc_mcu7t5v0__endcap
XFILLER_10_502 VPWR VPWR VGND VGND gf180mcu_fd_sc_mcu7t5v0__fillcap_16
XFILLER_10_524 VPWR VPWR VGND VGND gf180mcu_fd_sc_mcu7t5v0__fill_1
Xrebuffer132 _383_/ZN _404_/A4 VPWR VPWR VGND VGND gf180mcu_fd_sc_mcu7t5v0__buf_8
Xrebuffer110 rebuffer147/Z _495_/A1 VPWR VPWR VGND VGND gf180mcu_fd_sc_mcu7t5v0__buf_8
Xrebuffer143 _349_/I _534_/B VPWR VPWR VGND VGND gf180mcu_fd_sc_mcu7t5v0__buf_8
X_456_ _456_/A1 _471_/B _456_/B _502_/B _457_/B2 VPWR VPWR VGND VGND gf180mcu_fd_sc_mcu7t5v0__oai211_2
X_525_ _647_/D _533_/A2 _529_/C VPWR VPWR VGND VGND gf180mcu_fd_sc_mcu7t5v0__nor2_2
XFILLER_9_322 VPWR VPWR VGND VGND gf180mcu_fd_sc_mcu7t5v0__fill_2
X_387_ _387_/I _644_/D VPWR VPWR VGND VGND gf180mcu_fd_sc_mcu7t5v0__clkinv_8
XTAP_TAPCELL_ROW_30_349 VPWR VGND gf180mcu_fd_sc_mcu7t5v0__filltie
XFILLER_5_594 VPWR VPWR VGND VGND gf180mcu_fd_sc_mcu7t5v0__fillcap_8
XTAP_TAPCELL_ROW_38_416 VPWR VGND gf180mcu_fd_sc_mcu7t5v0__filltie
XFILLER_36_454 VPWR VPWR VGND VGND gf180mcu_fd_sc_mcu7t5v0__fill_1
XFILLER_36_34 VPWR VPWR VGND VGND gf180mcu_fd_sc_mcu7t5v0__fill_1
X_310_ _648_/Q _350_/B VPWR VPWR VGND VGND gf180mcu_fd_sc_mcu7t5v0__clkinv_1
XFILLER_10_321 VPWR VPWR VGND VGND gf180mcu_fd_sc_mcu7t5v0__fill_2
XFILLER_10_376 VPWR VPWR VGND VGND gf180mcu_fd_sc_mcu7t5v0__fill_1
XFILLER_10_387 VPWR VPWR VGND VGND gf180mcu_fd_sc_mcu7t5v0__fillcap_4
XTAP_TAPCELL_ROW_9_163 VPWR VGND gf180mcu_fd_sc_mcu7t5v0__filltie
XFILLER_2_597 VPWR VPWR VGND VGND gf180mcu_fd_sc_mcu7t5v0__fillcap_8
X_439_ _439_/A1 _439_/A2 _449_/A3 _471_/A3 VPWR VPWR VGND VGND gf180mcu_fd_sc_mcu7t5v0__nor3_4
X_508_ _505_/C _508_/A2 _508_/Z VPWR VPWR VGND VGND gf180mcu_fd_sc_mcu7t5v0__or2_1
XFILLER_20_107 VPWR VPWR VGND VGND gf180mcu_fd_sc_mcu7t5v0__fillcap_64
Xwire77 _631_/Q uio_out[5] VPWR VPWR VGND VGND gf180mcu_fd_sc_mcu7t5v0__buf_8
XFILLER_36_251 VPWR VPWR VGND VGND gf180mcu_fd_sc_mcu7t5v0__fill_2
Xwire55 wire55/I wire55/Z VPWR VPWR VGND VGND gf180mcu_fd_sc_mcu7t5v0__buf_8
XTAP_TAPCELL_ROW_6_144 VPWR VGND gf180mcu_fd_sc_mcu7t5v0__filltie
XFILLER_6_177 VPWR VPWR VGND VGND gf180mcu_fd_sc_mcu7t5v0__fillcap_64
XPHY_EDGE_ROW_25_Left_64 VPWR VGND gf180mcu_fd_sc_mcu7t5v0__endcap
XTAP_TAPCELL_ROW_3_114 VPWR VGND gf180mcu_fd_sc_mcu7t5v0__filltie
XFILLER_12_449 VPWR VPWR VGND VGND gf180mcu_fd_sc_mcu7t5v0__fillcap_4
XFILLER_20_471 VPWR VPWR VGND VGND gf180mcu_fd_sc_mcu7t5v0__fill_2
XFILLER_3_136 VPWR VPWR VGND VGND gf180mcu_fd_sc_mcu7t5v0__fillcap_4
XTAP_TAPCELL_ROW_17_238 VPWR VGND gf180mcu_fd_sc_mcu7t5v0__filltie
XFILLER_28_593 VPWR VPWR VGND VGND gf180mcu_fd_sc_mcu7t5v0__fill_2
XFILLER_15_276 VPWR VPWR VGND VGND gf180mcu_fd_sc_mcu7t5v0__fillcap_4
XFILLER_17_2 VPWR VPWR VGND VGND gf180mcu_fd_sc_mcu7t5v0__fillcap_64
XFILLER_21_268 VPWR VPWR VGND VGND gf180mcu_fd_sc_mcu7t5v0__fillcap_4
XFILLER_12_279 VPWR VPWR VGND VGND gf180mcu_fd_sc_mcu7t5v0__fillcap_16
XTAP_TAPCELL_ROW_14_208 VPWR VGND gf180mcu_fd_sc_mcu7t5v0__filltie
XTAP_TAPCELL_ROW_22_274 VPWR VGND gf180mcu_fd_sc_mcu7t5v0__filltie
XPHY_EDGE_ROW_7_Right_7 VPWR VGND gf180mcu_fd_sc_mcu7t5v0__endcap
XTAP_TAPCELL_ROW_36_399 VPWR VGND gf180mcu_fd_sc_mcu7t5v0__filltie
XFILLER_14_37 VPWR VPWR VGND VGND gf180mcu_fd_sc_mcu7t5v0__fillcap_64
XPHY_EDGE_ROW_12_Left_51 VPWR VGND gf180mcu_fd_sc_mcu7t5v0__endcap
X_610_ _610_/A1 _610_/A2 _612_/A1 VPWR VPWR VGND VGND gf180mcu_fd_sc_mcu7t5v0__nand2_1
X_472_ _646_/D _516_/A1 _441_/B _473_/B VPWR VPWR VGND VGND gf180mcu_fd_sc_mcu7t5v0__nand3_1
X_541_ _514_/Z _543_/A2 _541_/B _542_/A3 VPWR VPWR VGND VGND gf180mcu_fd_sc_mcu7t5v0__aoi21_1
XTAP_TAPCELL_ROW_27_322 VPWR VGND gf180mcu_fd_sc_mcu7t5v0__filltie
XTAP_TAPCELL_ROW_33_369 VPWR VGND gf180mcu_fd_sc_mcu7t5v0__filltie
Xrebuffer111 _359_/ZN fanout50/I VPWR VPWR VGND VGND gf180mcu_fd_sc_mcu7t5v0__buf_8
XFILLER_1_212 VPWR VPWR VGND VGND gf180mcu_fd_sc_mcu7t5v0__fillcap_64
X_386_ _404_/A4 _390_/B1 _386_/ZN VPWR VPWR VGND VGND gf180mcu_fd_sc_mcu7t5v0__nand2_4
X_455_ _421_/C _388_/Z _455_/Z VPWR VPWR VGND VGND gf180mcu_fd_sc_mcu7t5v0__and2_1
X_524_ _488_/C _645_/D wire25/Z _533_/A2 VPWR VPWR VGND VGND gf180mcu_fd_sc_mcu7t5v0__nor3_4
XFILLER_5_562 VPWR VPWR VGND VGND gf180mcu_fd_sc_mcu7t5v0__fillcap_32
XTAP_TAPCELL_ROW_38_417 VPWR VGND gf180mcu_fd_sc_mcu7t5v0__filltie
XFILLER_27_422 VPWR VPWR VGND VGND gf180mcu_fd_sc_mcu7t5v0__fill_1
XFILLER_10_311 VPWR VPWR VGND VGND gf180mcu_fd_sc_mcu7t5v0__fillcap_4
XFILLER_22_171 VPWR VPWR VGND VGND gf180mcu_fd_sc_mcu7t5v0__fillcap_4
XTAP_TAPCELL_ROW_9_164 VPWR VGND gf180mcu_fd_sc_mcu7t5v0__filltie
XFILLER_2_521 VPWR VPWR VGND VGND gf180mcu_fd_sc_mcu7t5v0__fillcap_4
XFILLER_9_142 VPWR VPWR VGND VGND gf180mcu_fd_sc_mcu7t5v0__fillcap_64
X_438_ _506_/A1 _407_/B _506_/B _500_/B1 VPWR VPWR VGND VGND gf180mcu_fd_sc_mcu7t5v0__oai21_4
X_507_ _506_/B _507_/A2 _515_/A2 _490_/B _508_/A2 VPWR VPWR VGND VGND gf180mcu_fd_sc_mcu7t5v0__aoi22_1
X_369_ _369_/A1 _370_/A2 _369_/Z VPWR VPWR VGND VGND gf180mcu_fd_sc_mcu7t5v0__xor2_2
XFILLER_3_72 VPWR VPWR VGND VGND gf180mcu_fd_sc_mcu7t5v0__fillcap_64
Xwire67 wire67/I wire67/Z VPWR VPWR VGND VGND gf180mcu_fd_sc_mcu7t5v0__buf_4
Xwire34 wire34/I wire34/Z VPWR VPWR VGND VGND gf180mcu_fd_sc_mcu7t5v0__buf_4
XFILLER_22_37 VPWR VPWR VGND VGND gf180mcu_fd_sc_mcu7t5v0__fillcap_64
XTAP_TAPCELL_ROW_6_145 VPWR VGND gf180mcu_fd_sc_mcu7t5v0__filltie
XFILLER_7_602 VPWR VPWR VGND VGND gf180mcu_fd_sc_mcu7t5v0__fill_2
XFILLER_6_101 VPWR VPWR VGND VGND gf180mcu_fd_sc_mcu7t5v0__fillcap_4
XFILLER_18_241 VPWR VPWR VGND VGND gf180mcu_fd_sc_mcu7t5v0__fillcap_4
XFILLER_18_263 VPWR VPWR VGND VGND gf180mcu_fd_sc_mcu7t5v0__fillcap_4
XFILLER_33_244 VPWR VPWR VGND VGND gf180mcu_fd_sc_mcu7t5v0__fill_2
XTAP_TAPCELL_ROW_11_180 VPWR VGND gf180mcu_fd_sc_mcu7t5v0__filltie
XTAP_TAPCELL_ROW_3_115 VPWR VGND gf180mcu_fd_sc_mcu7t5v0__filltie
XFILLER_30_247 VPWR VPWR VGND VGND gf180mcu_fd_sc_mcu7t5v0__fillcap_16
XFILLER_7_487 VPWR VPWR VGND VGND gf180mcu_fd_sc_mcu7t5v0__fill_2
XFILLER_34_597 VPWR VPWR VGND VGND gf180mcu_fd_sc_mcu7t5v0__fillcap_8
XTAP_TAPCELL_ROW_14_209 VPWR VGND gf180mcu_fd_sc_mcu7t5v0__filltie
XFILLER_12_247 VPWR VPWR VGND VGND gf180mcu_fd_sc_mcu7t5v0__fillcap_32
XTAP_TAPCELL_ROW_22_275 VPWR VGND gf180mcu_fd_sc_mcu7t5v0__filltie
XFILLER_4_457 VPWR VPWR VGND VGND gf180mcu_fd_sc_mcu7t5v0__fillcap_64
XFILLER_16_597 VPWR VPWR VGND VGND gf180mcu_fd_sc_mcu7t5v0__fillcap_8
XFILLER_38_100 VPWR VPWR VGND VGND gf180mcu_fd_sc_mcu7t5v0__fill_2
XFILLER_38_122 VPWR VPWR VGND VGND gf180mcu_fd_sc_mcu7t5v0__fillcap_8
Xclkbuf_3_5__f_clk clkbuf_0_clk/Z _655_/CLK VPWR VPWR VGND VGND gf180mcu_fd_sc_mcu7t5v0__clkbuf_8
XFILLER_26_317 VPWR VPWR VGND VGND gf180mcu_fd_sc_mcu7t5v0__fill_2
XFILLER_22_523 VPWR VPWR VGND VGND gf180mcu_fd_sc_mcu7t5v0__fill_2
XFILLER_1_416 VPWR VPWR VGND VGND gf180mcu_fd_sc_mcu7t5v0__fillcap_4
XFILLER_30_37 VPWR VPWR VGND VGND gf180mcu_fd_sc_mcu7t5v0__fillcap_64
X_540_ _540_/A1 _542_/A2 _649_/D _542_/B VPWR VPWR VGND VGND gf180mcu_fd_sc_mcu7t5v0__oai21_1
X_471_ _471_/A1 _471_/A2 _471_/A3 _471_/B _473_/A1 VPWR VPWR VGND VGND gf180mcu_fd_sc_mcu7t5v0__oai31_2
XTAP_TAPCELL_ROW_27_323 VPWR VGND gf180mcu_fd_sc_mcu7t5v0__filltie
X_669_ _669_/I uo_out[3] VPWR VPWR VGND VGND gf180mcu_fd_sc_mcu7t5v0__buf_8
XFILLER_35_136 VPWR VPWR VGND VGND gf180mcu_fd_sc_mcu7t5v0__fillcap_4
XFILLER_27_604 VPWR VPWR VGND VGND gf180mcu_fd_sc_mcu7t5v0__fill_1
Xrebuffer112 _387_/I _407_/B VPWR VPWR VGND VGND gf180mcu_fd_sc_mcu7t5v0__buf_8
XFILLER_17_136 VPWR VPWR VGND VGND gf180mcu_fd_sc_mcu7t5v0__fillcap_4
X_523_ _645_/Q _532_/C _523_/A3 _529_/B VPWR VPWR VGND VGND gf180mcu_fd_sc_mcu7t5v0__nand3_1
X_454_ _454_/A1 _454_/A2 _454_/B _454_/C _456_/A1 VPWR VPWR VGND VGND gf180mcu_fd_sc_mcu7t5v0__aoi211_4
X_385_ _385_/A1 _385_/A2 _385_/B _396_/C VPWR VPWR VGND VGND gf180mcu_fd_sc_mcu7t5v0__oai21_4
XTAP_TAPCELL_ROW_38_418 VPWR VGND gf180mcu_fd_sc_mcu7t5v0__filltie
XFILLER_10_323 VPWR VPWR VGND VGND gf180mcu_fd_sc_mcu7t5v0__fill_1
XTAP_TAPCELL_ROW_9_165 VPWR VGND gf180mcu_fd_sc_mcu7t5v0__filltie
XFILLER_7_2 VPWR VPWR VGND VGND gf180mcu_fd_sc_mcu7t5v0__fillcap_64
X_506_ _506_/A1 _407_/B _506_/B _515_/A2 VPWR VPWR VGND VGND gf180mcu_fd_sc_mcu7t5v0__aoi21_4
X_437_ _437_/A1 _523_/A3 _437_/B _441_/B VPWR VPWR VGND VGND gf180mcu_fd_sc_mcu7t5v0__aoi21_2
X_368_ _369_/A1 _385_/A1 _559_/B _375_/B VPWR VPWR VGND VGND gf180mcu_fd_sc_mcu7t5v0__aoi21_2
XFILLER_5_393 VPWR VPWR VGND VGND gf180mcu_fd_sc_mcu7t5v0__fill_1
Xwire79 _630_/Q uio_out[4] VPWR VPWR VGND VGND gf180mcu_fd_sc_mcu7t5v0__buf_8
Xwire46 _422_/C wire46/Z VPWR VPWR VGND VGND gf180mcu_fd_sc_mcu7t5v0__buf_4
XFILLER_27_264 VPWR VPWR VGND VGND gf180mcu_fd_sc_mcu7t5v0__fill_2
XPHY_EDGE_ROW_29_Right_29 VPWR VGND gf180mcu_fd_sc_mcu7t5v0__endcap
XPHY_EDGE_ROW_38_Right_38 VPWR VGND gf180mcu_fd_sc_mcu7t5v0__endcap
XFILLER_33_212 VPWR VPWR VGND VGND gf180mcu_fd_sc_mcu7t5v0__fillcap_32
XTAP_TAPCELL_ROW_11_181 VPWR VGND gf180mcu_fd_sc_mcu7t5v0__filltie
XTAP_TAPCELL_ROW_3_116 VPWR VGND gf180mcu_fd_sc_mcu7t5v0__filltie
XFILLER_15_212 VPWR VPWR VGND VGND gf180mcu_fd_sc_mcu7t5v0__fillcap_64
XFILLER_7_455 VPWR VPWR VGND VGND gf180mcu_fd_sc_mcu7t5v0__fillcap_32
XFILLER_7_422 VPWR VPWR VGND VGND gf180mcu_fd_sc_mcu7t5v0__fill_2
XFILLER_2_171 VPWR VPWR VGND VGND gf180mcu_fd_sc_mcu7t5v0__fillcap_4
XFILLER_9_72 VPWR VPWR VGND VGND gf180mcu_fd_sc_mcu7t5v0__fillcap_64
XFILLER_28_37 VPWR VPWR VGND VGND gf180mcu_fd_sc_mcu7t5v0__fillcap_64
XTAP_TAPCELL_ROW_22_276 VPWR VGND gf180mcu_fd_sc_mcu7t5v0__filltie
XFILLER_22_2 VPWR VPWR VGND VGND gf180mcu_fd_sc_mcu7t5v0__fillcap_32
Xload_slew80 uio_out[3] _669_/I VPWR VPWR VGND VGND gf180mcu_fd_sc_mcu7t5v0__buf_4
XFILLER_17_329 VPWR VPWR VGND VGND gf180mcu_fd_sc_mcu7t5v0__fill_2
XFILLER_13_557 VPWR VPWR VGND VGND gf180mcu_fd_sc_mcu7t5v0__fill_2
X_470_ _649_/D _470_/A2 _470_/A3 _470_/B _619_/D VPWR VPWR VGND VGND gf180mcu_fd_sc_mcu7t5v0__oai31_2
XTAP_TAPCELL_ROW_35_390 VPWR VGND gf180mcu_fd_sc_mcu7t5v0__filltie
X_668_ _668_/I uo_out[2] VPWR VPWR VGND VGND gf180mcu_fd_sc_mcu7t5v0__buf_8
X_599_ _599_/A1 _599_/A2 _601_/B _639_/D VPWR VPWR VGND VGND gf180mcu_fd_sc_mcu7t5v0__aoi21_1
XFILLER_10_527 VPWR VPWR VGND VGND gf180mcu_fd_sc_mcu7t5v0__fillcap_64
Xrebuffer113 _403_/A4 _396_/B VPWR VPWR VGND VGND gf180mcu_fd_sc_mcu7t5v0__buf_8
Xrebuffer102 _495_/A1 _450_/A1 VPWR VPWR VGND VGND gf180mcu_fd_sc_mcu7t5v0__buf_8
Xrebuffer124 fanout49/I _494_/B VPWR VPWR VGND VGND gf180mcu_fd_sc_mcu7t5v0__buf_8
XTAP_TAPCELL_ROW_32_360 VPWR VGND gf180mcu_fd_sc_mcu7t5v0__filltie
X_453_ _453_/A1 _453_/A2 _453_/B _475_/B _457_/A3 VPWR VPWR VGND VGND gf180mcu_fd_sc_mcu7t5v0__aoi211_4
X_522_ _515_/B _468_/C _522_/A3 _536_/A2 _530_/A1 VPWR VPWR VGND VGND gf180mcu_fd_sc_mcu7t5v0__nand4_1
XFILLER_32_107 VPWR VPWR VGND VGND gf180mcu_fd_sc_mcu7t5v0__fillcap_64
XFILLER_9_314 VPWR VPWR VGND VGND gf180mcu_fd_sc_mcu7t5v0__fillcap_8
X_384_ _384_/A1 _384_/A2 _603_/B _390_/B1 VPWR VPWR VGND VGND gf180mcu_fd_sc_mcu7t5v0__aoi21_4
XTAP_TAPCELL_ROW_38_419 VPWR VGND gf180mcu_fd_sc_mcu7t5v0__filltie
XFILLER_36_457 VPWR VPWR VGND VGND gf180mcu_fd_sc_mcu7t5v0__fill_1
XFILLER_36_37 VPWR VPWR VGND VGND gf180mcu_fd_sc_mcu7t5v0__fillcap_64
XFILLER_14_107 VPWR VPWR VGND VGND gf180mcu_fd_sc_mcu7t5v0__fillcap_64
XFILLER_6_317 VPWR VPWR VGND VGND gf180mcu_fd_sc_mcu7t5v0__fillcap_16
XTAP_TAPCELL_ROW_9_166 VPWR VGND gf180mcu_fd_sc_mcu7t5v0__filltie
X_436_ _458_/A1 _523_/A3 _476_/A2 VPWR VPWR VGND VGND gf180mcu_fd_sc_mcu7t5v0__nand2_1
XFILLER_18_457 VPWR VPWR VGND VGND gf180mcu_fd_sc_mcu7t5v0__fill_2
X_505_ _523_/A3 _505_/A2 _532_/A2 _538_/A2 _505_/C _509_/A1 VPWR VPWR VGND VGND gf180mcu_fd_sc_mcu7t5v0__oai221_1
X_367_ _367_/A1 _367_/A2 _643_/D VPWR VPWR VGND VGND gf180mcu_fd_sc_mcu7t5v0__nor2_4
Xwire25 wire25/I wire25/Z VPWR VPWR VGND VGND gf180mcu_fd_sc_mcu7t5v0__buf_2
XFILLER_15_427 VPWR VPWR VGND VGND gf180mcu_fd_sc_mcu7t5v0__fill_2
XFILLER_7_604 VPWR VPWR VGND VGND gf180mcu_fd_sc_mcu7t5v0__fill_1
X_419_ _515_/B _648_/D _484_/B VPWR VPWR VGND VGND gf180mcu_fd_sc_mcu7t5v0__nor2_2
XTAP_TAPCELL_ROW_11_182 VPWR VGND gf180mcu_fd_sc_mcu7t5v0__filltie
XTAP_TAPCELL_ROW_3_117 VPWR VGND gf180mcu_fd_sc_mcu7t5v0__filltie
XFILLER_28_585 VPWR VPWR VGND VGND gf180mcu_fd_sc_mcu7t5v0__fillcap_8
XFILLER_11_430 VPWR VPWR VGND VGND gf180mcu_fd_sc_mcu7t5v0__fill_2
XFILLER_7_489 VPWR VPWR VGND VGND gf180mcu_fd_sc_mcu7t5v0__fill_1
XPHY_EDGE_ROW_29_Left_68 VPWR VGND gf180mcu_fd_sc_mcu7t5v0__endcap
XTAP_TAPCELL_ROW_16_230 VPWR VGND gf180mcu_fd_sc_mcu7t5v0__filltie
XFILLER_25_588 VPWR VPWR VGND VGND gf180mcu_fd_sc_mcu7t5v0__fillcap_16
XFILLER_20_271 VPWR VPWR VGND VGND gf180mcu_fd_sc_mcu7t5v0__fillcap_4
XTAP_TAPCELL_ROW_22_277 VPWR VGND gf180mcu_fd_sc_mcu7t5v0__filltie
XFILLER_11_282 VPWR VPWR VGND VGND gf180mcu_fd_sc_mcu7t5v0__fillcap_32
XTAP_TAPCELL_ROW_13_200 VPWR VGND gf180mcu_fd_sc_mcu7t5v0__filltie
XFILLER_16_577 VPWR VPWR VGND VGND gf180mcu_fd_sc_mcu7t5v0__fillcap_16
XFILLER_31_536 VPWR VPWR VGND VGND gf180mcu_fd_sc_mcu7t5v0__fill_2
XFILLER_38_168 VPWR VPWR VGND VGND gf180mcu_fd_sc_mcu7t5v0__fill_2
XFILLER_38_135 VPWR VPWR VGND VGND gf180mcu_fd_sc_mcu7t5v0__fill_1
XFILLER_3_492 VPWR VPWR VGND VGND gf180mcu_fd_sc_mcu7t5v0__fillcap_64
XFILLER_15_2 VPWR VPWR VGND VGND gf180mcu_fd_sc_mcu7t5v0__fillcap_64
XFILLER_26_319 VPWR VPWR VGND VGND gf180mcu_fd_sc_mcu7t5v0__fill_1
Xload_slew123 _613_/B _385_/B VPWR VPWR VGND VGND gf180mcu_fd_sc_mcu7t5v0__clkbuf_4
XFILLER_30_591 VPWR VPWR VGND VGND gf180mcu_fd_sc_mcu7t5v0__fillcap_4
XFILLER_25_352 VPWR VPWR VGND VGND gf180mcu_fd_sc_mcu7t5v0__fill_1
XTAP_TAPCELL_ROW_35_391 VPWR VGND gf180mcu_fd_sc_mcu7t5v0__filltie
X_598_ _639_/Q _602_/A2 _599_/A2 VPWR VPWR VGND VGND gf180mcu_fd_sc_mcu7t5v0__nand2_1
XFILLER_16_341 VPWR VPWR VGND VGND gf180mcu_fd_sc_mcu7t5v0__fill_1
XFILLER_16_374 VPWR VPWR VGND VGND gf180mcu_fd_sc_mcu7t5v0__fill_1
X_667_ _667_/I uo_out[1] VPWR VPWR VGND VGND gf180mcu_fd_sc_mcu7t5v0__buf_8
XPHY_EDGE_ROW_16_Left_55 VPWR VGND gf180mcu_fd_sc_mcu7t5v0__endcap
Xrebuffer103 _369_/Z _373_/A1 VPWR VPWR VGND VGND gf180mcu_fd_sc_mcu7t5v0__buf_8
XTAP_TAPCELL_ROW_32_361 VPWR VGND gf180mcu_fd_sc_mcu7t5v0__filltie
XFILLER_34_171 VPWR VPWR VGND VGND gf180mcu_fd_sc_mcu7t5v0__fillcap_4
Xrebuffer158 _356_/A3 _350_/A2 VPWR VPWR VGND VGND gf180mcu_fd_sc_mcu7t5v0__buf_8
Xrebuffer125 _359_/ZN fanout49/I VPWR VPWR VGND VGND gf180mcu_fd_sc_mcu7t5v0__buf_8
Xrebuffer147 fanout50/I rebuffer147/Z VPWR VPWR VGND VGND gf180mcu_fd_sc_mcu7t5v0__buf_8
Xrebuffer114 _352_/I _520_/B VPWR VPWR VGND VGND gf180mcu_fd_sc_mcu7t5v0__buf_8
X_452_ _471_/B _643_/D _452_/A3 _453_/B VPWR VPWR VGND VGND gf180mcu_fd_sc_mcu7t5v0__nor3_4
X_521_ _506_/B _532_/A2 _536_/A2 VPWR VPWR VGND VGND gf180mcu_fd_sc_mcu7t5v0__nand2_2
X_383_ _383_/A1 _383_/A2 _383_/B _383_/ZN VPWR VPWR VGND VGND gf180mcu_fd_sc_mcu7t5v0__oai21_4
XFILLER_15_72 VPWR VPWR VGND VGND gf180mcu_fd_sc_mcu7t5v0__fillcap_64
XTAP_TAPCELL_ROW_38_409 VPWR VGND gf180mcu_fd_sc_mcu7t5v0__filltie
XFILLER_16_171 VPWR VPWR VGND VGND gf180mcu_fd_sc_mcu7t5v0__fillcap_4
XFILLER_8_381 VPWR VPWR VGND VGND gf180mcu_fd_sc_mcu7t5v0__fillcap_4
XTAP_TAPCELL_ROW_9_167 VPWR VGND gf180mcu_fd_sc_mcu7t5v0__filltie
X_504_ _523_/A3 _505_/A2 _505_/C _511_/B2 VPWR VPWR VGND VGND gf180mcu_fd_sc_mcu7t5v0__oai21_1
X_366_ _383_/A2 _366_/A2 _385_/B _433_/A3 VPWR VPWR VGND VGND gf180mcu_fd_sc_mcu7t5v0__oai21_4
X_435_ _506_/A1 _407_/B _496_/A2 VPWR VPWR VGND VGND gf180mcu_fd_sc_mcu7t5v0__nor2_4
XFILLER_33_428 VPWR VPWR VGND VGND gf180mcu_fd_sc_mcu7t5v0__fill_1
XFILLER_24_428 VPWR VPWR VGND VGND gf180mcu_fd_sc_mcu7t5v0__fill_1
XFILLER_32_483 VPWR VPWR VGND VGND gf180mcu_fd_sc_mcu7t5v0__fill_2
XTAP_TAPCELL_ROW_6_137 VPWR VGND gf180mcu_fd_sc_mcu7t5v0__filltie
XFILLER_27_244 VPWR VPWR VGND VGND gf180mcu_fd_sc_mcu7t5v0__fillcap_16
XFILLER_27_266 VPWR VPWR VGND VGND gf180mcu_fd_sc_mcu7t5v0__fill_1
XFILLER_10_177 VPWR VPWR VGND VGND gf180mcu_fd_sc_mcu7t5v0__fillcap_64
XFILLER_38_509 VPWR VPWR VGND VGND gf180mcu_fd_sc_mcu7t5v0__fill_1
XFILLER_2_387 VPWR VPWR VGND VGND gf180mcu_fd_sc_mcu7t5v0__fillcap_64
X_418_ _418_/A1 _418_/A2 _418_/A3 _406_/Z _418_/B2 _432_/A1 VPWR VPWR VGND VGND gf180mcu_fd_sc_mcu7t5v0__oai32_4
X_349_ _349_/I _647_/D VPWR VPWR VGND VGND gf180mcu_fd_sc_mcu7t5v0__clkinv_4
XTAP_TAPCELL_ROW_11_183 VPWR VGND gf180mcu_fd_sc_mcu7t5v0__filltie
XTAP_TAPCELL_ROW_3_118 VPWR VGND gf180mcu_fd_sc_mcu7t5v0__filltie
XTAP_TAPCELL_ROW_19_250 VPWR VGND gf180mcu_fd_sc_mcu7t5v0__filltie
XFILLER_24_247 VPWR VPWR VGND VGND gf180mcu_fd_sc_mcu7t5v0__fillcap_16
XFILLER_20_453 VPWR VPWR VGND VGND gf180mcu_fd_sc_mcu7t5v0__fill_2
XFILLER_28_597 VPWR VPWR VGND VGND gf180mcu_fd_sc_mcu7t5v0__fillcap_8
XPHY_EDGE_ROW_4_Left_43 VPWR VGND gf180mcu_fd_sc_mcu7t5v0__endcap
XFILLER_23_72 VPWR VPWR VGND VGND gf180mcu_fd_sc_mcu7t5v0__fillcap_64
XFILLER_21_206 VPWR VPWR VGND VGND gf180mcu_fd_sc_mcu7t5v0__fillcap_4
XTAP_TAPCELL_ROW_22_278 VPWR VGND gf180mcu_fd_sc_mcu7t5v0__filltie
XPHY_EDGE_ROW_30_Left_69 VPWR VGND gf180mcu_fd_sc_mcu7t5v0__endcap
XFILLER_16_545 VPWR VPWR VGND VGND gf180mcu_fd_sc_mcu7t5v0__fillcap_32
XTAP_TAPCELL_ROW_13_201 VPWR VGND gf180mcu_fd_sc_mcu7t5v0__filltie
XFILLER_7_276 VPWR VPWR VGND VGND gf180mcu_fd_sc_mcu7t5v0__fillcap_4
Xload_slew82 uio_out[2] _668_/I VPWR VPWR VGND VGND gf180mcu_fd_sc_mcu7t5v0__buf_4
XFILLER_29_136 VPWR VPWR VGND VGND gf180mcu_fd_sc_mcu7t5v0__fillcap_4
XFILLER_13_537 VPWR VPWR VGND VGND gf180mcu_fd_sc_mcu7t5v0__fillcap_16
XFILLER_13_559 VPWR VPWR VGND VGND gf180mcu_fd_sc_mcu7t5v0__fill_1
XFILLER_21_592 VPWR VPWR VGND VGND gf180mcu_fd_sc_mcu7t5v0__fillcap_8
X_597_ _597_/A1 _597_/A2 _603_/B _638_/D VPWR VPWR VGND VGND gf180mcu_fd_sc_mcu7t5v0__aoi21_1
X_666_ _666_/I uo_out[0] VPWR VPWR VGND VGND gf180mcu_fd_sc_mcu7t5v0__buf_8
XFILLER_10_518 VPWR VPWR VGND VGND gf180mcu_fd_sc_mcu7t5v0__fillcap_4
Xrebuffer126 _433_/A3 _367_/A1 VPWR VPWR VGND VGND gf180mcu_fd_sc_mcu7t5v0__buf_8
Xrebuffer104 _378_/ZN max_cap41/I VPWR VPWR VGND VGND gf180mcu_fd_sc_mcu7t5v0__clkbuf_8
Xrebuffer115 _323_/I _400_/C VPWR VPWR VGND VGND gf180mcu_fd_sc_mcu7t5v0__buf_8
XTAP_TAPCELL_ROW_32_362 VPWR VGND gf180mcu_fd_sc_mcu7t5v0__filltie
X_520_ _534_/B _520_/A2 _520_/B _520_/C _531_/A2 VPWR VPWR VGND VGND gf180mcu_fd_sc_mcu7t5v0__aoi211_2
XFILLER_13_367 VPWR VPWR VGND VGND gf180mcu_fd_sc_mcu7t5v0__fillcap_4
X_451_ _481_/A1 _481_/A2 _646_/D _453_/A2 VPWR VPWR VGND VGND gf180mcu_fd_sc_mcu7t5v0__aoi21_4
X_382_ _382_/A1 _382_/A2 _644_/Q _403_/A4 VPWR VPWR VGND VGND gf180mcu_fd_sc_mcu7t5v0__aoi21_4
XFILLER_31_72 VPWR VPWR VGND VGND gf180mcu_fd_sc_mcu7t5v0__fillcap_64
XPHY_EDGE_ROW_33_Left_72 VPWR VGND gf180mcu_fd_sc_mcu7t5v0__endcap
X_649_ _649_/D _649_/CLK _649_/Q VPWR VPWR VGND VGND gf180mcu_fd_sc_mcu7t5v0__dffq_1
XFILLER_31_142 VPWR VPWR VGND VGND gf180mcu_fd_sc_mcu7t5v0__fillcap_64
XFILLER_10_337 VPWR VPWR VGND VGND gf180mcu_fd_sc_mcu7t5v0__fillcap_4
XTAP_TAPCELL_ROW_9_168 VPWR VGND gf180mcu_fd_sc_mcu7t5v0__filltie
X_503_ _503_/I _510_/B VPWR VPWR VGND VGND gf180mcu_fd_sc_mcu7t5v0__clkinv_1
XFILLER_13_142 VPWR VPWR VGND VGND gf180mcu_fd_sc_mcu7t5v0__fillcap_64
X_365_ _382_/A2 _382_/A1 _559_/B _434_/A3 VPWR VPWR VGND VGND gf180mcu_fd_sc_mcu7t5v0__aoi21_4
X_434_ _644_/Q _434_/A2 _434_/A3 _490_/B VPWR VPWR VGND VGND gf180mcu_fd_sc_mcu7t5v0__nand3_2
XFILLER_5_385 VPWR VPWR VGND VGND gf180mcu_fd_sc_mcu7t5v0__fillcap_8
XFILLER_5_352 VPWR VPWR VGND VGND gf180mcu_fd_sc_mcu7t5v0__fillcap_16
XTAP_TAPCELL_ROW_6_138 VPWR VGND gf180mcu_fd_sc_mcu7t5v0__filltie
XFILLER_27_212 VPWR VPWR VGND VGND gf180mcu_fd_sc_mcu7t5v0__fillcap_32
XFILLER_10_101 VPWR VPWR VGND VGND gf180mcu_fd_sc_mcu7t5v0__fillcap_4
XFILLER_11_602 VPWR VPWR VGND VGND gf180mcu_fd_sc_mcu7t5v0__fill_2
XFILLER_2_311 VPWR VPWR VGND VGND gf180mcu_fd_sc_mcu7t5v0__fillcap_4
XFILLER_5_2 VPWR VPWR VGND VGND gf180mcu_fd_sc_mcu7t5v0__fillcap_64
XPHY_EDGE_ROW_16_Right_16 VPWR VGND gf180mcu_fd_sc_mcu7t5v0__endcap
XFILLER_18_267 VPWR VPWR VGND VGND gf180mcu_fd_sc_mcu7t5v0__fill_2
X_417_ _536_/A1 _417_/A2 _648_/D _417_/C _418_/B2 VPWR VPWR VGND VGND gf180mcu_fd_sc_mcu7t5v0__oai211_4
X_348_ _348_/A1 _400_/C _348_/A3 _349_/I VPWR VPWR VGND VGND gf180mcu_fd_sc_mcu7t5v0__nand3_4
XPHY_EDGE_ROW_25_Right_25 VPWR VGND gf180mcu_fd_sc_mcu7t5v0__endcap
XFILLER_38_2 VPWR VPWR VGND VGND gf180mcu_fd_sc_mcu7t5v0__fillcap_32
XTAP_TAPCELL_ROW_11_184 VPWR VGND gf180mcu_fd_sc_mcu7t5v0__filltie
XTAP_TAPCELL_ROW_3_119 VPWR VGND gf180mcu_fd_sc_mcu7t5v0__filltie
XPHY_EDGE_ROW_34_Right_34 VPWR VGND gf180mcu_fd_sc_mcu7t5v0__endcap
XFILLER_37_598 VPWR VPWR VGND VGND gf180mcu_fd_sc_mcu7t5v0__fillcap_4
XTAP_TAPCELL_ROW_19_251 VPWR VGND gf180mcu_fd_sc_mcu7t5v0__filltie
XFILLER_11_410 VPWR VPWR VGND VGND gf180mcu_fd_sc_mcu7t5v0__fillcap_8
XFILLER_19_576 VPWR VPWR VGND VGND gf180mcu_fd_sc_mcu7t5v0__fillcap_16
XTAP_TAPCELL_ROW_22_279 VPWR VGND gf180mcu_fd_sc_mcu7t5v0__filltie
Xclkbuf_3_0__f_clk clkbuf_0_clk/Z _633_/CLK VPWR VPWR VGND VGND gf180mcu_fd_sc_mcu7t5v0__clkbuf_8
XTAP_TAPCELL_ROW_13_202 VPWR VGND gf180mcu_fd_sc_mcu7t5v0__filltie
XFILLER_16_524 VPWR VPWR VGND VGND gf180mcu_fd_sc_mcu7t5v0__fill_1
XFILLER_38_148 VPWR VPWR VGND VGND gf180mcu_fd_sc_mcu7t5v0__fillcap_16
XFILLER_38_104 VPWR VPWR VGND VGND gf180mcu_fd_sc_mcu7t5v0__fill_1
Xload_slew72 uio_out[7] _673_/I VPWR VPWR VGND VGND gf180mcu_fd_sc_mcu7t5v0__buf_4
XFILLER_30_560 VPWR VPWR VGND VGND gf180mcu_fd_sc_mcu7t5v0__fill_2
XPHY_EDGE_ROW_2_Right_2 VPWR VGND gf180mcu_fd_sc_mcu7t5v0__endcap
XTAP_TAPCELL_ROW_27_316 VPWR VGND gf180mcu_fd_sc_mcu7t5v0__filltie
XFILLER_4_247 VPWR VPWR VGND VGND gf180mcu_fd_sc_mcu7t5v0__fillcap_64
XFILLER_29_72 VPWR VPWR VGND VGND gf180mcu_fd_sc_mcu7t5v0__fillcap_64
XFILLER_16_387 VPWR VPWR VGND VGND gf180mcu_fd_sc_mcu7t5v0__fill_1
X_596_ _638_/Q _602_/A2 _597_/A2 VPWR VPWR VGND VGND gf180mcu_fd_sc_mcu7t5v0__nand2_1
XFILLER_8_597 VPWR VPWR VGND VGND gf180mcu_fd_sc_mcu7t5v0__fillcap_8
XFILLER_12_593 VPWR VPWR VGND VGND gf180mcu_fd_sc_mcu7t5v0__fill_2
XFILLER_20_2 VPWR VPWR VGND VGND gf180mcu_fd_sc_mcu7t5v0__fillcap_32
XFILLER_26_107 VPWR VPWR VGND VGND gf180mcu_fd_sc_mcu7t5v0__fillcap_64
Xrebuffer105 _370_/Z _399_/B VPWR VPWR VGND VGND gf180mcu_fd_sc_mcu7t5v0__buf_8
Xrebuffer127 rebuffer142/Z _420_/A1 VPWR VPWR VGND VGND gf180mcu_fd_sc_mcu7t5v0__buf_8
Xrebuffer116 _383_/A1 _385_/A1 VPWR VPWR VGND VGND gf180mcu_fd_sc_mcu7t5v0__buf_8
XTAP_TAPCELL_ROW_32_363 VPWR VGND gf180mcu_fd_sc_mcu7t5v0__filltie
XFILLER_1_206 VPWR VPWR VGND VGND gf180mcu_fd_sc_mcu7t5v0__fillcap_4
X_381_ _646_/D wire55/Z _468_/A2 _418_/A2 VPWR VPWR VGND VGND gf180mcu_fd_sc_mcu7t5v0__nor3_4
X_450_ _450_/A1 _450_/A2 _481_/A2 VPWR VPWR VGND VGND gf180mcu_fd_sc_mcu7t5v0__nor2_4
XFILLER_5_556 VPWR VPWR VGND VGND gf180mcu_fd_sc_mcu7t5v0__fillcap_4
X_648_ _648_/D _649_/CLK _648_/Q VPWR VPWR VGND VGND gf180mcu_fd_sc_mcu7t5v0__dffq_1
XFILLER_8_350 VPWR VPWR VGND VGND gf180mcu_fd_sc_mcu7t5v0__fillcap_4
X_579_ _579_/A1 _579_/A2 _603_/B _631_/D VPWR VPWR VGND VGND gf180mcu_fd_sc_mcu7t5v0__aoi21_2
XTAP_TAPCELL_ROW_9_169 VPWR VGND gf180mcu_fd_sc_mcu7t5v0__filltie
X_502_ _502_/A1 _502_/A2 _502_/B _503_/I VPWR VPWR VGND VGND gf180mcu_fd_sc_mcu7t5v0__oai21_1
X_433_ _383_/B wire67/I _433_/A3 wire25/I VPWR VPWR VGND VGND gf180mcu_fd_sc_mcu7t5v0__nor3_4
XFILLER_9_136 VPWR VPWR VGND VGND gf180mcu_fd_sc_mcu7t5v0__fillcap_4
X_364_ _369_/A1 _383_/A1 _364_/B _434_/A2 VPWR VPWR VGND VGND gf180mcu_fd_sc_mcu7t5v0__oai21_4
XFILLER_3_66 VPWR VPWR VGND VGND gf180mcu_fd_sc_mcu7t5v0__fillcap_4
Xwire28 wire28/I wire28/Z VPWR VPWR VGND VGND gf180mcu_fd_sc_mcu7t5v0__buf_4
XTAP_TAPCELL_ROW_6_139 VPWR VGND gf180mcu_fd_sc_mcu7t5v0__filltie
XFILLER_37_72 VPWR VPWR VGND VGND gf180mcu_fd_sc_mcu7t5v0__fillcap_64
XFILLER_14_452 VPWR VPWR VGND VGND gf180mcu_fd_sc_mcu7t5v0__fill_2
X_416_ _515_/B _468_/C _536_/A1 VPWR VPWR VGND VGND gf180mcu_fd_sc_mcu7t5v0__nand2_2
X_347_ _350_/A1 _356_/A3 _348_/A3 VPWR VPWR VGND VGND gf180mcu_fd_sc_mcu7t5v0__nand2_2
XTAP_TAPCELL_ROW_11_185 VPWR VGND gf180mcu_fd_sc_mcu7t5v0__filltie
XTAP_TAPCELL_ROW_19_252 VPWR VGND gf180mcu_fd_sc_mcu7t5v0__filltie
XFILLER_11_422 VPWR VPWR VGND VGND gf180mcu_fd_sc_mcu7t5v0__fillcap_8
XFILLER_23_282 VPWR VPWR VGND VGND gf180mcu_fd_sc_mcu7t5v0__fill_1
XTAP_TAPCELL_ROW_25_299 VPWR VGND gf180mcu_fd_sc_mcu7t5v0__filltie
XFILLER_19_522 VPWR VPWR VGND VGND gf180mcu_fd_sc_mcu7t5v0__fill_2
XFILLER_14_271 VPWR VPWR VGND VGND gf180mcu_fd_sc_mcu7t5v0__fill_2
XTAP_TAPCELL_ROW_16_222 VPWR VGND gf180mcu_fd_sc_mcu7t5v0__filltie
XFILLER_20_241 VPWR VPWR VGND VGND gf180mcu_fd_sc_mcu7t5v0__fillcap_4
XFILLER_20_263 VPWR VPWR VGND VGND gf180mcu_fd_sc_mcu7t5v0__fillcap_8
XTAP_TAPCELL_ROW_13_203 VPWR VGND gf180mcu_fd_sc_mcu7t5v0__filltie
XFILLER_7_212 VPWR VPWR VGND VGND gf180mcu_fd_sc_mcu7t5v0__fillcap_64
Xload_slew84 uio_out[1] _667_/I VPWR VPWR VGND VGND gf180mcu_fd_sc_mcu7t5v0__buf_4
XFILLER_38_138 VPWR VPWR VGND VGND gf180mcu_fd_sc_mcu7t5v0__fillcap_4
Xload_slew51 _425_/A2 _464_/C VPWR VPWR VGND VGND gf180mcu_fd_sc_mcu7t5v0__buf_4
Xload_slew62 _369_/Z _400_/B VPWR VPWR VGND VGND gf180mcu_fd_sc_mcu7t5v0__buf_4
XFILLER_30_583 VPWR VPWR VGND VGND gf180mcu_fd_sc_mcu7t5v0__fillcap_8
XTAP_TAPCELL_ROW_27_317 VPWR VGND gf180mcu_fd_sc_mcu7t5v0__filltie
XFILLER_0_410 VPWR VPWR VGND VGND gf180mcu_fd_sc_mcu7t5v0__fillcap_32
X_595_ _595_/A1 _595_/A2 _603_/B _637_/D VPWR VPWR VGND VGND gf180mcu_fd_sc_mcu7t5v0__aoi21_1
XFILLER_16_333 VPWR VPWR VGND VGND gf180mcu_fd_sc_mcu7t5v0__fillcap_8
XFILLER_28_171 VPWR VPWR VGND VGND gf180mcu_fd_sc_mcu7t5v0__fillcap_4
XFILLER_8_510 VPWR VPWR VGND VGND gf180mcu_fd_sc_mcu7t5v0__fillcap_8
XFILLER_13_2 VPWR VPWR VGND VGND gf180mcu_fd_sc_mcu7t5v0__fillcap_64
Xrebuffer117 _390_/ZN _443_/A2 VPWR VPWR VGND VGND gf180mcu_fd_sc_mcu7t5v0__buf_8
XTAP_TAPCELL_ROW_32_364 VPWR VGND gf180mcu_fd_sc_mcu7t5v0__filltie
Xrebuffer106 rebuffer131/Z _363_/A1 VPWR VPWR VGND VGND gf180mcu_fd_sc_mcu7t5v0__buf_8
X_380_ _449_/A1 _506_/A1 _468_/A2 VPWR VPWR VGND VGND gf180mcu_fd_sc_mcu7t5v0__nand2_4
XFILLER_0_240 VPWR VPWR VGND VGND gf180mcu_fd_sc_mcu7t5v0__fillcap_32
X_578_ _639_/Q _586_/A2 _582_/B1 input7/Z _579_/A2 VPWR VPWR VGND VGND gf180mcu_fd_sc_mcu7t5v0__aoi22_1
X_647_ _647_/D _649_/CLK _647_/Q VPWR VPWR VGND VGND gf180mcu_fd_sc_mcu7t5v0__dffq_1
.ends
